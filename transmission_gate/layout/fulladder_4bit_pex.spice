* NGSPICE file created from fulladder_4bit.ext - technology: sky130A

.subckt fulladder_4bit A1 B1 A3 B3 A2 B2 Cin A0 B0 Cout Sum1 Sum3 Sum2 Sum0 GND VDD
X0 Sum1 a_2659_n940# a_2872_n940# VDD sky130_fd_pr__pfet_01v8 ad=0.4403 pd=1.975 as=0.4403 ps=1.975 w=1.295 l=0.15
X1 Sum3 a_6008_n940# a_6764_n940# GND sky130_fd_pr__nfet_01v8 ad=0.1428 pd=1.1 as=0.1428 ps=1.1 w=0.42 l=0.15
X2 a_3370_n940# a_4062_n940# Sum2 VDD sky130_fd_pr__pfet_01v8 ad=0.4403 pd=1.975 as=0.4403 ps=1.975 w=1.295 l=0.15
X3 a_566_n940# a_170_n940# VDD VDD sky130_fd_pr__pfet_01v8 ad=0.60217 pd=3.52 as=0.34317 ps=3.12 w=1.295 l=0.15
X4 VDD A3 a_5629_n940# VDD sky130_fd_pr__pfet_01v8 ad=0.28275 pd=2.185 as=0.87652 ps=4.7 w=1.885 l=0.15
X5 B1 a_1737_n940# a_2116_n940# GND sky130_fd_pr__nfet_01v8 ad=0.28365 pd=2.15 as=0.2074 ps=1.29 w=0.61 l=0.15
X6 Cin a_170_n940# Sum0 VDD sky130_fd_pr__pfet_01v8 ad=0.4403 pd=1.975 as=0.4403 ps=1.975 w=1.295 l=0.15
X7 VDD a_6008_n940# a_6551_n940# VDD sky130_fd_pr__pfet_01v8 ad=0.19425 pd=1.595 as=0.60217 ps=3.52 w=1.295 l=0.15
X8 a_1424_n940# a_2659_n940# Sum1 GND sky130_fd_pr__nfet_01v8 ad=0.1428 pd=1.1 as=0.1428 ps=1.1 w=0.42 l=0.15
X9 a_3370_n940# a_2512_n940# a_1424_n940# VDD sky130_fd_pr__pfet_01v8 ad=0.4403 pd=1.975 as=0.4403 ps=1.975 w=1.295 l=0.15
X10 a_5842_n940# B3 VDD VDD sky130_fd_pr__pfet_01v8 ad=0.6409 pd=2.565 as=0.28275 ps=2.185 w=1.885 l=0.15
X11 GND A2 a_3683_n940# GND sky130_fd_pr__nfet_01v8 ad=0.0915 pd=0.91 as=0.28365 ps=2.15 w=0.61 l=0.15
X12 a_6764_n940# a_5316_n940# VDD VDD sky130_fd_pr__pfet_01v8 ad=0.4403 pd=1.975 as=0.19425 ps=1.595 w=1.295 l=0.15
X13 GND a_4062_n940# a_4605_n940# GND sky130_fd_pr__nfet_01v8 ad=0.063 pd=0.72 as=0.1953 ps=1.77 w=0.42 l=0.15
X14 GND A0 a_n209_n940# GND sky130_fd_pr__nfet_01v8 ad=0.0915 pd=0.91 as=0.28365 ps=2.15 w=0.61 l=0.15
X15 a_1424_n940# a_170_n940# Cin GND sky130_fd_pr__nfet_01v8 ad=0.1428 pd=1.1 as=0.1428 ps=1.1 w=0.42 l=0.15
X16 a_3896_n940# B2 GND GND sky130_fd_pr__nfet_01v8 ad=0.2074 pd=1.29 as=0.0915 ps=0.91 w=0.61 l=0.15
X17 Cout a_6008_n940# a_5316_n940# GND sky130_fd_pr__nfet_01v8 ad=0.1428 pd=1.1 as=0.1428 ps=1.1 w=0.42 l=0.15
X18 VDD a_170_n940# a_713_n940# VDD sky130_fd_pr__pfet_01v8 ad=0.19425 pd=1.595 as=0.60217 ps=3.52 w=1.295 l=0.15
X19 A0 a_170_n940# a_1424_n940# VDD sky130_fd_pr__pfet_01v8 ad=0.60217 pd=3.52 as=0.4403 ps=1.975 w=1.295 l=0.15
X20 a_2116_n940# a_1737_n940# a_1950_n940# VDD sky130_fd_pr__pfet_01v8 ad=0.6409 pd=2.565 as=0.6409 ps=2.565 w=1.885 l=0.15
X21 A3 a_6008_n940# Cout VDD sky130_fd_pr__pfet_01v8 ad=0.60217 pd=3.52 as=0.4403 ps=1.975 w=1.295 l=0.15
X22 a_4818_n940# a_3370_n940# GND GND sky130_fd_pr__nfet_01v8 ad=0.1428 pd=1.1 as=0.063 ps=0.72 w=0.42 l=0.15
X23 a_170_n940# a_n209_n940# a_4_n940# VDD sky130_fd_pr__pfet_01v8 ad=0.6409 pd=2.565 as=0.6409 ps=2.565 w=1.885 l=0.15
X24 Sum2 a_4605_n940# a_4818_n940# VDD sky130_fd_pr__pfet_01v8 ad=0.4403 pd=1.975 as=0.4403 ps=1.975 w=1.295 l=0.15
X25 a_2512_n940# a_2116_n940# VDD VDD sky130_fd_pr__pfet_01v8 ad=0.60217 pd=3.52 as=0.34317 ps=3.12 w=1.295 l=0.15
X26 A1 a_2116_n940# a_3370_n940# VDD sky130_fd_pr__pfet_01v8 ad=0.60217 pd=3.52 as=0.4403 ps=1.975 w=1.295 l=0.15
X27 B3 A3 a_6008_n940# VDD sky130_fd_pr__pfet_01v8 ad=0.87652 pd=4.7 as=0.6409 ps=2.565 w=1.885 l=0.15
X28 A2 a_4458_n940# a_5316_n940# GND sky130_fd_pr__nfet_01v8 ad=0.1953 pd=1.77 as=0.1428 ps=1.1 w=0.42 l=0.15
X29 a_4458_n940# a_4062_n940# VDD VDD sky130_fd_pr__pfet_01v8 ad=0.60217 pd=3.52 as=0.34317 ps=3.12 w=1.295 l=0.15
X30 Sum0 a_170_n940# a_926_n940# GND sky130_fd_pr__nfet_01v8 ad=0.1428 pd=1.1 as=0.1428 ps=1.1 w=0.42 l=0.15
X31 a_6404_n940# a_6008_n940# GND GND sky130_fd_pr__nfet_01v8 ad=0.1953 pd=1.77 as=0.1113 ps=1.37 w=0.42 l=0.15
X32 a_5316_n940# a_6008_n940# Sum3 VDD sky130_fd_pr__pfet_01v8 ad=0.4403 pd=1.975 as=0.4403 ps=1.975 w=1.295 l=0.15
X33 B2 a_3683_n940# a_4062_n940# GND sky130_fd_pr__nfet_01v8 ad=0.28365 pd=2.15 as=0.2074 ps=1.29 w=0.61 l=0.15
X34 VDD A1 a_1737_n940# VDD sky130_fd_pr__pfet_01v8 ad=0.28275 pd=2.185 as=0.87652 ps=4.7 w=1.885 l=0.15
X35 Sum1 a_2116_n940# a_2872_n940# GND sky130_fd_pr__nfet_01v8 ad=0.1428 pd=1.1 as=0.1428 ps=1.1 w=0.42 l=0.15
X36 B0 A0 a_170_n940# VDD sky130_fd_pr__pfet_01v8 ad=0.87652 pd=4.7 as=0.6409 ps=2.565 w=1.885 l=0.15
X37 a_1950_n940# B1 VDD VDD sky130_fd_pr__pfet_01v8 ad=0.6409 pd=2.565 as=0.28275 ps=2.185 w=1.885 l=0.15
X38 VDD a_2116_n940# a_2659_n940# VDD sky130_fd_pr__pfet_01v8 ad=0.19425 pd=1.595 as=0.60217 ps=3.52 w=1.295 l=0.15
X39 a_566_n940# a_170_n940# GND GND sky130_fd_pr__nfet_01v8 ad=0.1953 pd=1.77 as=0.1113 ps=1.37 w=0.42 l=0.15
X40 a_3370_n940# a_4605_n940# Sum2 GND sky130_fd_pr__nfet_01v8 ad=0.1428 pd=1.1 as=0.1428 ps=1.1 w=0.42 l=0.15
X41 a_5316_n940# a_4458_n940# a_3370_n940# VDD sky130_fd_pr__pfet_01v8 ad=0.4403 pd=1.975 as=0.4403 ps=1.975 w=1.295 l=0.15
X42 GND A3 a_5629_n940# GND sky130_fd_pr__nfet_01v8 ad=0.0915 pd=0.91 as=0.28365 ps=2.15 w=0.61 l=0.15
X43 a_2872_n940# a_1424_n940# VDD VDD sky130_fd_pr__pfet_01v8 ad=0.4403 pd=1.975 as=0.19425 ps=1.595 w=1.295 l=0.15
X44 Cin a_713_n940# Sum0 GND sky130_fd_pr__nfet_01v8 ad=0.1428 pd=1.1 as=0.1428 ps=1.1 w=0.42 l=0.15
X45 GND a_6008_n940# a_6551_n940# GND sky130_fd_pr__nfet_01v8 ad=0.063 pd=0.72 as=0.1953 ps=1.77 w=0.42 l=0.15
X46 a_4_n940# B0 VDD VDD sky130_fd_pr__pfet_01v8 ad=0.6409 pd=2.565 as=0.28275 ps=2.185 w=1.885 l=0.15
X47 a_926_n940# Cin VDD VDD sky130_fd_pr__pfet_01v8 ad=0.4403 pd=1.975 as=0.19425 ps=1.595 w=1.295 l=0.15
X48 a_6008_n940# a_5629_n940# a_5842_n940# VDD sky130_fd_pr__pfet_01v8 ad=0.6409 pd=2.565 as=0.6409 ps=2.565 w=1.885 l=0.15
X49 a_3370_n940# a_2116_n940# a_1424_n940# GND sky130_fd_pr__nfet_01v8 ad=0.1428 pd=1.1 as=0.1428 ps=1.1 w=0.42 l=0.15
X50 a_5842_n940# B3 GND GND sky130_fd_pr__nfet_01v8 ad=0.2074 pd=1.29 as=0.0915 ps=0.91 w=0.61 l=0.15
X51 a_4062_n940# a_3683_n940# a_3896_n940# VDD sky130_fd_pr__pfet_01v8 ad=0.6409 pd=2.565 as=0.6409 ps=2.565 w=1.885 l=0.15
X52 a_6764_n940# a_5316_n940# GND GND sky130_fd_pr__nfet_01v8 ad=0.1428 pd=1.1 as=0.063 ps=0.72 w=0.42 l=0.15
X53 Sum3 a_6551_n940# a_6764_n940# VDD sky130_fd_pr__pfet_01v8 ad=0.4403 pd=1.975 as=0.4403 ps=1.975 w=1.295 l=0.15
X54 GND a_170_n940# a_713_n940# GND sky130_fd_pr__nfet_01v8 ad=0.063 pd=0.72 as=0.1953 ps=1.77 w=0.42 l=0.15
X55 A0 a_566_n940# a_1424_n940# GND sky130_fd_pr__nfet_01v8 ad=0.1953 pd=1.77 as=0.1428 ps=1.1 w=0.42 l=0.15
X56 a_2116_n940# A1 a_1950_n940# GND sky130_fd_pr__nfet_01v8 ad=0.2074 pd=1.29 as=0.2074 ps=1.29 w=0.61 l=0.15
X57 A3 a_6404_n940# Cout GND sky130_fd_pr__nfet_01v8 ad=0.1953 pd=1.77 as=0.1428 ps=1.1 w=0.42 l=0.15
X58 B1 A1 a_2116_n940# VDD sky130_fd_pr__pfet_01v8 ad=0.87652 pd=4.7 as=0.6409 ps=2.565 w=1.885 l=0.15
X59 a_170_n940# A0 a_4_n940# GND sky130_fd_pr__nfet_01v8 ad=0.2074 pd=1.29 as=0.2074 ps=1.29 w=0.61 l=0.15
X60 Sum2 a_4062_n940# a_4818_n940# GND sky130_fd_pr__nfet_01v8 ad=0.1428 pd=1.1 as=0.1428 ps=1.1 w=0.42 l=0.15
X61 a_1424_n940# a_2116_n940# Sum1 VDD sky130_fd_pr__pfet_01v8 ad=0.4403 pd=1.975 as=0.4403 ps=1.975 w=1.295 l=0.15
X62 a_2512_n940# a_2116_n940# GND GND sky130_fd_pr__nfet_01v8 ad=0.1953 pd=1.77 as=0.1113 ps=1.37 w=0.42 l=0.15
X63 VDD A2 a_3683_n940# VDD sky130_fd_pr__pfet_01v8 ad=0.28275 pd=2.185 as=0.87652 ps=4.7 w=1.885 l=0.15
X64 A1 a_2512_n940# a_3370_n940# GND sky130_fd_pr__nfet_01v8 ad=0.1953 pd=1.77 as=0.1428 ps=1.1 w=0.42 l=0.15
X65 B3 a_5629_n940# a_6008_n940# GND sky130_fd_pr__nfet_01v8 ad=0.28365 pd=2.15 as=0.2074 ps=1.29 w=0.61 l=0.15
X66 a_4458_n940# a_4062_n940# GND GND sky130_fd_pr__nfet_01v8 ad=0.1953 pd=1.77 as=0.1113 ps=1.37 w=0.42 l=0.15
X67 VDD A0 a_n209_n940# VDD sky130_fd_pr__pfet_01v8 ad=0.28275 pd=2.185 as=0.87652 ps=4.7 w=1.885 l=0.15
X68 a_1424_n940# a_566_n940# Cin VDD sky130_fd_pr__pfet_01v8 ad=0.4403 pd=1.975 as=0.4403 ps=1.975 w=1.295 l=0.15
X69 a_3896_n940# B2 VDD VDD sky130_fd_pr__pfet_01v8 ad=0.6409 pd=2.565 as=0.28275 ps=2.185 w=1.885 l=0.15
X70 VDD a_4062_n940# a_4605_n940# VDD sky130_fd_pr__pfet_01v8 ad=0.19425 pd=1.595 as=0.60217 ps=3.52 w=1.295 l=0.15
X71 Cout a_6404_n940# a_5316_n940# VDD sky130_fd_pr__pfet_01v8 ad=0.4403 pd=1.975 as=0.4403 ps=1.975 w=1.295 l=0.15
X72 a_5316_n940# a_6551_n940# Sum3 GND sky130_fd_pr__nfet_01v8 ad=0.1428 pd=1.1 as=0.1428 ps=1.1 w=0.42 l=0.15
X73 a_4818_n940# a_3370_n940# VDD VDD sky130_fd_pr__pfet_01v8 ad=0.4403 pd=1.975 as=0.19425 ps=1.595 w=1.295 l=0.15
X74 GND A1 a_1737_n940# GND sky130_fd_pr__nfet_01v8 ad=0.0915 pd=0.91 as=0.28365 ps=2.15 w=0.61 l=0.15
X75 B0 a_n209_n940# a_170_n940# GND sky130_fd_pr__nfet_01v8 ad=0.28365 pd=2.15 as=0.2074 ps=1.29 w=0.61 l=0.15
X76 a_1950_n940# B1 GND GND sky130_fd_pr__nfet_01v8 ad=0.2074 pd=1.29 as=0.0915 ps=0.91 w=0.61 l=0.15
X77 GND a_2116_n940# a_2659_n940# GND sky130_fd_pr__nfet_01v8 ad=0.063 pd=0.72 as=0.1953 ps=1.77 w=0.42 l=0.15
X78 a_5316_n940# a_4062_n940# a_3370_n940# GND sky130_fd_pr__nfet_01v8 ad=0.1428 pd=1.1 as=0.1428 ps=1.1 w=0.42 l=0.15
X79 A2 a_4062_n940# a_5316_n940# VDD sky130_fd_pr__pfet_01v8 ad=0.60217 pd=3.52 as=0.4403 ps=1.975 w=1.295 l=0.15
X80 a_2872_n940# a_1424_n940# GND GND sky130_fd_pr__nfet_01v8 ad=0.1428 pd=1.1 as=0.063 ps=0.72 w=0.42 l=0.15
X81 Sum0 a_713_n940# a_926_n940# VDD sky130_fd_pr__pfet_01v8 ad=0.4403 pd=1.975 as=0.4403 ps=1.975 w=1.295 l=0.15
X82 a_6404_n940# a_6008_n940# VDD VDD sky130_fd_pr__pfet_01v8 ad=0.60217 pd=3.52 as=0.34317 ps=3.12 w=1.295 l=0.15
X83 a_4_n940# B0 GND GND sky130_fd_pr__nfet_01v8 ad=0.2074 pd=1.29 as=0.0915 ps=0.91 w=0.61 l=0.15
X84 a_926_n940# Cin GND GND sky130_fd_pr__nfet_01v8 ad=0.1428 pd=1.1 as=0.063 ps=0.72 w=0.42 l=0.15
X85 a_6008_n940# A3 a_5842_n940# GND sky130_fd_pr__nfet_01v8 ad=0.2074 pd=1.29 as=0.2074 ps=1.29 w=0.61 l=0.15
X86 B2 A2 a_4062_n940# VDD sky130_fd_pr__pfet_01v8 ad=0.87652 pd=4.7 as=0.6409 ps=2.565 w=1.885 l=0.15
X87 a_4062_n940# A2 a_3896_n940# GND sky130_fd_pr__nfet_01v8 ad=0.2074 pd=1.29 as=0.2074 ps=1.29 w=0.61 l=0.15
C0 B2 a_1424_n940# 0.00412f
C1 A0 A1 0.01856f
C2 a_713_n940# a_2116_n940# 0
C3 a_3370_n940# Sum1 0
C4 A3 Cout 0.20065f
C5 A3 a_6008_n940# 0.48936f
C6 a_5316_n940# a_4062_n940# 0.12022f
C7 a_6551_n940# a_5316_n940# 0.25518f
C8 Cin a_2116_n940# 0
C9 a_4458_n940# B3 0.00119f
C10 a_4062_n940# a_3896_n940# 0.20993f
C11 Sum3 VDD 0.02942f
C12 a_n209_n940# a_566_n940# 0.00137f
C13 a_2116_n940# VDD 0.29f
C14 a_4062_n940# a_1424_n940# 0
C15 a_2872_n940# a_3370_n940# 0
C16 a_926_n940# a_713_n940# 0.15803f
C17 A0 a_2116_n940# 0
C18 a_5842_n940# a_6404_n940# 0
C19 a_4458_n940# A3 0.02018f
C20 Sum2 a_4818_n940# 0.1663f
C21 a_4062_n940# a_6404_n940# 0
C22 a_926_n940# Cin 0.09416f
C23 a_6551_n940# a_6404_n940# 0.3937f
C24 a_5629_n940# VDD 0.24921f
C25 Sum0 a_713_n940# 0.11006f
C26 a_926_n940# VDD 0.10026f
C27 A2 a_4818_n940# 0.02596f
C28 a_3370_n940# a_4605_n940# 0.25518f
C29 Sum2 a_2512_n940# 0
C30 Cout VDD 0.02866f
C31 Sum0 Cin 0.20145f
C32 a_6008_n940# VDD 0.28492f
C33 A0 a_926_n940# 0.02596f
C34 a_4458_n940# a_2659_n940# 0
C35 A1 a_2116_n940# 0.48936f
C36 a_6764_n940# a_4062_n940# 0
C37 a_6551_n940# a_6764_n940# 0.15229f
C38 Sum0 VDD 0.02942f
C39 B2 B3 0
C40 a_5316_n940# a_4818_n940# 0
C41 a_170_n940# a_1424_n940# 0.12054f
C42 Sum0 A0 0.02504f
C43 A2 a_2512_n940# 0.02018f
C44 B1 A2 0
C45 a_4458_n940# VDD 0.1529f
C46 B2 A3 0
C47 a_5842_n940# B3 0.10296f
C48 a_926_n940# A1 0
C49 Sum2 a_3683_n940# 0
C50 a_566_n940# a_2659_n940# 0
C51 a_1737_n940# A2 0
C52 a_713_n940# a_566_n940# 0.3937f
C53 a_4062_n940# B3 0.00129f
C54 a_6551_n940# B3 0.00272f
C55 a_2512_n940# a_3896_n940# 0
C56 Sum0 A1 0
C57 a_5629_n940# Sum3 0
C58 a_3683_n940# A2 0.24827f
C59 A3 a_5842_n940# 0.0871f
C60 a_566_n940# Cin 0.11268f
C61 B2 a_2659_n940# 0
C62 a_2512_n940# a_1424_n940# 0.14904f
C63 B1 a_1424_n940# 0.04618f
C64 a_n209_n940# a_170_n940# 0.16664f
C65 A3 a_4062_n940# 0.00548f
C66 a_6008_n940# Sum3 0.1345f
C67 A3 a_6551_n940# 0.0279f
C68 a_566_n940# VDD 0.1529f
C69 a_4458_n940# A1 0
C70 a_3683_n940# a_5316_n940# 0
C71 A0 a_566_n940# 0.3255f
C72 a_1737_n940# a_1424_n940# 0.14112f
C73 a_3683_n940# a_3896_n940# 0.16386f
C74 B2 VDD 0.26164f
C75 a_5629_n940# Cout 0
C76 a_5629_n940# a_6008_n940# 0.16013f
C77 a_4062_n940# a_2659_n940# 0
C78 A2 Sum1 0
C79 a_3683_n940# a_1424_n940# 0.0027f
C80 a_1950_n940# a_1424_n940# 0.03544f
C81 a_4458_n940# Sum3 0
C82 B0 a_1424_n940# 0
C83 a_4_n940# a_1424_n940# 0
C84 a_4458_n940# a_2116_n940# 0
C85 a_6008_n940# Cout 0.11882f
C86 a_566_n940# A1 0.02018f
C87 B1 a_n209_n940# 0
C88 Sum0 a_926_n940# 0.1663f
C89 Sum2 a_3370_n940# 0.20283f
C90 a_5842_n940# VDD 0.1683f
C91 a_4818_n940# B3 0
C92 a_4062_n940# VDD 0.29f
C93 a_6551_n940# VDD 0.15973f
C94 a_4458_n940# a_5629_n940# 0.00861f
C95 A2 a_2872_n940# 0
C96 a_1737_n940# a_n209_n940# 0
C97 B2 A1 0.00134f
C98 A2 a_3370_n940# 0.0387f
C99 A3 a_4818_n940# 0
C100 Sum2 a_4605_n940# 0.11006f
C101 a_170_n940# a_2659_n940# 0
C102 Sum1 a_1424_n940# 0.20283f
C103 a_566_n940# a_2116_n940# 0.00104f
C104 a_4458_n940# a_6008_n940# 0.00104f
C105 a_170_n940# a_713_n940# 0.29274f
C106 B0 a_n209_n940# 0.15656f
C107 a_5316_n940# a_3370_n940# 0.1756f
C108 a_n209_n940# a_4_n940# 0.17036f
C109 A2 a_4605_n940# 0.0279f
C110 a_170_n940# Cin 0.36797f
C111 B2 a_2116_n940# 0.00129f
C112 a_3370_n940# a_3896_n940# 0.03544f
C113 a_4062_n940# A1 0
C114 a_2872_n940# a_1424_n940# 0.12035f
C115 a_170_n940# VDD 0.28992f
C116 a_926_n940# a_566_n940# 0.02527f
C117 a_5316_n940# a_4605_n940# 0.00236f
C118 a_3683_n940# B3 0
C119 a_3370_n940# a_1424_n940# 0.1756f
C120 A0 a_170_n940# 0.48936f
C121 B2 a_5629_n940# 0.0016f
C122 a_2512_n940# a_2659_n940# 0.39371f
C123 B1 a_2659_n940# 0.00272f
C124 Sum0 a_566_n940# 0.02949f
C125 a_3896_n940# a_4605_n940# 0
C126 a_2512_n940# a_713_n940# 0
C127 a_4062_n940# Sum3 0
C128 a_4818_n940# VDD 0.10026f
C129 a_6551_n940# Sum3 0.11006f
C130 B1 a_713_n940# 0
C131 a_3683_n940# A3 0
C132 a_4062_n940# a_2116_n940# 0.00549f
C133 a_4605_n940# a_1424_n940# 0
C134 a_5629_n940# a_5842_n940# 0.16386f
C135 a_1737_n940# a_2659_n940# 0.00673f
C136 B1 Cin 0.00407f
C137 a_6404_n940# a_4605_n940# 0
C138 a_170_n940# A1 0.00548f
C139 a_1737_n940# a_713_n940# 0.00575f
C140 a_2512_n940# VDD 0.1529f
C141 a_5629_n940# a_4062_n940# 0.00744f
C142 B1 VDD 0.26164f
C143 a_5629_n940# a_6551_n940# 0.00667f
C144 A0 a_2512_n940# 0
C145 a_3683_n940# a_2659_n940# 0.00577f
C146 a_6008_n940# a_5842_n940# 0.20993f
C147 a_1950_n940# a_2659_n940# 0
C148 A0 B1 0.00134f
C149 a_1737_n940# Cin 0.00264f
C150 a_1950_n940# a_713_n940# 0
C151 a_6008_n940# a_4062_n940# 0.00549f
C152 a_4458_n940# B2 0.07097f
C153 B0 a_713_n940# 0.00272f
C154 a_6551_n940# Cout 0.00187f
C155 a_6551_n940# a_6008_n940# 0.29108f
C156 a_713_n940# a_4_n940# 0
C157 a_1737_n940# VDD 0.24921f
C158 a_170_n940# a_2116_n940# 0.00549f
C159 a_1950_n940# Cin 0
C160 A0 a_1737_n940# 0.26852f
C161 B0 Cin 0.00519f
C162 Cin a_4_n940# 0
C163 a_3370_n940# B3 0.00412f
C164 a_3683_n940# VDD 0.24921f
C165 a_4458_n940# a_5842_n940# 0
C166 a_1950_n940# VDD 0.1683f
C167 a_2512_n940# A1 0.3255f
C168 B0 VDD 0.26164f
C169 a_4_n940# VDD 0.1683f
C170 B1 A1 0.25966f
C171 Sum1 a_2659_n940# 0.11006f
C172 A0 a_1950_n940# 0
C173 A0 B0 0.25966f
C174 A0 a_4_n940# 0.0871f
C175 a_4458_n940# a_4062_n940# 0.2246f
C176 a_4818_n940# a_2116_n940# 0
C177 a_4458_n940# a_6551_n940# 0
C178 Sum2 A2 0.02504f
C179 A3 a_3370_n940# 0
C180 a_170_n940# a_926_n940# 0.0825f
C181 B3 a_4605_n940# 0
C182 a_1737_n940# A1 0.24827f
C183 a_5629_n940# a_4818_n940# 0
C184 a_2512_n940# a_2116_n940# 0.2246f
C185 Sum2 a_5316_n940# 0
C186 Sum0 a_170_n940# 0.1345f
C187 B1 a_2116_n940# 0.32061f
C188 a_2872_n940# a_2659_n940# 0.15229f
C189 Sum1 VDD 0.02942f
C190 a_3683_n940# A1 0.26852f
C191 A3 a_4605_n940# 0
C192 a_1950_n940# A1 0.0871f
C193 a_3370_n940# a_2659_n940# 0.00236f
C194 B0 A1 0
C195 A2 a_5316_n940# 0.25491f
C196 a_1737_n940# a_2116_n940# 0.16012f
C197 B1 a_926_n940# 0
C198 a_4605_n940# a_2659_n940# 0
C199 A2 a_3896_n940# 0.0871f
C200 B2 a_4062_n940# 0.32061f
C201 a_2872_n940# VDD 0.10026f
C202 a_3683_n940# a_2116_n940# 0.00744f
C203 a_1950_n940# a_2116_n940# 0.20993f
C204 a_3370_n940# VDD 0.14158f
C205 A2 a_1424_n940# 0
C206 a_4458_n940# a_4818_n940# 0.02527f
C207 Sum1 A1 0.02504f
C208 Sum0 B1 0
C209 a_1737_n940# a_926_n940# 0
C210 A2 a_6404_n940# 0
C211 a_3683_n940# a_5629_n940# 0
C212 a_4062_n940# a_5842_n940# 0
C213 a_170_n940# a_566_n940# 0.22726f
C214 a_6551_n940# a_5842_n940# 0
C215 a_4605_n940# VDD 0.15973f
C216 a_4458_n940# a_2512_n940# 0.00186f
C217 Sum0 a_1737_n940# 0.00111f
C218 a_6551_n940# a_4062_n940# 0
C219 B0 a_926_n940# 0
C220 a_5316_n940# a_6404_n940# 0.14922f
C221 a_3896_n940# a_1424_n940# 0
C222 a_2872_n940# A1 0.02596f
C223 Sum1 a_2116_n940# 0.1345f
C224 a_3370_n940# A1 0.25491f
C225 Sum0 B0 0
C226 a_6764_n940# a_5316_n940# 0.12035f
C227 Sum2 B3 0
C228 B2 a_4818_n940# 0
C229 a_2512_n940# a_566_n940# 0.00186f
C230 A1 a_4605_n940# 0
C231 a_4458_n940# a_3683_n940# 0.00137f
C232 B1 a_566_n940# 0.00119f
C233 a_2872_n940# a_2116_n940# 0.08162f
C234 a_3370_n940# a_2116_n940# 0.12022f
C235 A2 B3 0.00134f
C236 Sum2 A3 0
C237 B2 a_2512_n940# 0.00119f
C238 a_1737_n940# a_566_n940# 0.00861f
C239 B1 B2 0
C240 a_5629_n940# a_3370_n940# 0.0027f
C241 a_n209_n940# a_1424_n940# 0
C242 a_6764_n940# a_6404_n940# 0.02527f
C243 a_4605_n940# a_2116_n940# 0
C244 a_4818_n940# a_4062_n940# 0.08162f
C245 a_5316_n940# B3 0.04618f
C246 A3 A2 0.01856f
C247 a_1950_n940# a_566_n940# 0
C248 B0 a_566_n940# 0.07097f
C249 a_566_n940# a_4_n940# 0
C250 B2 a_1737_n940# 0
C251 a_6008_n940# a_3370_n940# 0
C252 a_5629_n940# a_4605_n940# 0.00575f
C253 a_2512_n940# a_4062_n940# 0.00104f
C254 A3 a_5316_n940# 0.0388f
C255 a_3683_n940# B2 0.15454f
C256 A2 a_2659_n940# 0
C257 a_6008_n940# a_4605_n940# 0
C258 a_6404_n940# B3 0.07097f
C259 Sum2 VDD 0.02942f
C260 a_4458_n940# a_3370_n940# 0.14904f
C261 a_566_n940# Sum1 0
C262 A3 a_6404_n940# 0.32657f
C263 a_3683_n940# a_4062_n940# 0.16013f
C264 A2 VDD 0.15361f
C265 a_3896_n940# a_2659_n940# 0
C266 a_6764_n940# B3 0
C267 a_2512_n940# a_170_n940# 0
C268 B2 Sum1 0
C269 a_4458_n940# a_4605_n940# 0.3937f
C270 B1 a_170_n940# 0.00129f
C271 a_2659_n940# a_1424_n940# 0.25508f
C272 a_2872_n940# a_566_n940# 0
C273 a_713_n940# a_1424_n940# 0.00245f
C274 a_5316_n940# VDD 0.14158f
C275 A3 a_6764_n940# 0.02596f
C276 a_2512_n940# a_4818_n940# 0
C277 a_1737_n940# a_170_n940# 0.00744f
C278 Cin a_1424_n940# 0.17232f
C279 a_3896_n940# VDD 0.1683f
C280 B2 a_2872_n940# 0
C281 A2 A1 0.01856f
C282 B2 a_3370_n940# 0.04618f
C283 a_1424_n940# VDD 0.14158f
C284 a_170_n940# a_1950_n940# 0
C285 B0 a_170_n940# 0.32325f
C286 A0 a_1424_n940# 0.25501f
C287 a_170_n940# a_4_n940# 0.20993f
C288 Sum2 a_2116_n940# 0
C289 B1 a_2512_n940# 0.07097f
C290 a_6404_n940# VDD 0.1529f
C291 A3 B3 0.25966f
C292 B2 a_4605_n940# 0.00272f
C293 a_3370_n940# a_5842_n940# 0
C294 a_n209_n940# a_713_n940# 0.00667f
C295 a_3683_n940# a_4818_n940# 0
C296 A2 a_2116_n940# 0.00548f
C297 Sum2 a_5629_n940# 0.00111f
C298 a_3896_n940# A1 0
C299 a_1737_n940# a_2512_n940# 0.00137f
C300 a_4062_n940# a_3370_n940# 0.46124f
C301 a_6551_n940# a_3370_n940# 0
C302 B1 a_1737_n940# 0.15454f
C303 a_6764_n940# VDD 0.10026f
C304 a_n209_n940# Cin 0
C305 A1 a_1424_n940# 0.0387f
C306 a_170_n940# Sum1 0
C307 a_5316_n940# Sum3 0.20283f
C308 a_5842_n940# a_4605_n940# 0
C309 a_3683_n940# a_2512_n940# 0.00861f
C310 a_n209_n940# VDD 0.20943f
C311 a_5629_n940# A2 0.26852f
C312 a_2512_n940# a_1950_n940# 0
C313 a_3683_n940# B1 0.0016f
C314 B1 a_1950_n940# 0.10296f
C315 B1 B0 0
C316 a_4062_n940# a_4605_n940# 0.29108f
C317 A0 a_n209_n940# 0.25136f
C318 a_6551_n940# a_4605_n940# 0
C319 a_3896_n940# a_2116_n940# 0
C320 a_6008_n940# A2 0
C321 a_5629_n940# a_5316_n940# 0.14113f
C322 a_3683_n940# a_1737_n940# 0
C323 a_1424_n940# a_2116_n940# 0.46124f
C324 a_1737_n940# a_1950_n940# 0.16386f
C325 a_2872_n940# a_170_n940# 0
C326 a_1737_n940# B0 0.0016f
C327 B3 VDD 0.26158f
C328 Sum2 a_4458_n940# 0.02949f
C329 Sum3 a_6404_n940# 0.02949f
C330 a_5316_n940# Cout 0.16984f
C331 a_6008_n940# a_5316_n940# 0.46124f
C332 a_2512_n940# Sum1 0.02949f
C333 a_n209_n940# A1 0
C334 B1 Sum1 0
C335 B0 a_4_n940# 0.10296f
C336 A3 VDD 0.14987f
C337 a_713_n940# a_2659_n940# 0
C338 a_4458_n940# A2 0.3255f
C339 a_4818_n940# a_3370_n940# 0.12035f
C340 a_926_n940# a_1424_n940# 0
C341 a_5629_n940# a_6404_n940# 0.00137f
C342 a_6764_n940# Sum3 0.1663f
C343 a_1737_n940# Sum1 0
C344 Cin a_2659_n940# 0
C345 a_2872_n940# a_2512_n940# 0.02527f
C346 a_4458_n940# a_5316_n940# 0.11428f
C347 Sum0 a_1424_n940# 0
C348 a_713_n940# Cin 0.15405f
C349 a_6008_n940# a_6404_n940# 0.2246f
C350 Cout a_6404_n940# 0.10853f
C351 B1 a_2872_n940# 0
C352 a_2659_n940# VDD 0.15973f
C353 a_4818_n940# a_4605_n940# 0.15229f
C354 a_2512_n940# a_3370_n940# 0.11428f
C355 a_3683_n940# Sum1 0.00111f
C356 B1 a_3370_n940# 0
C357 a_5629_n940# a_6764_n940# 0
C358 A0 a_2659_n940# 0
C359 a_713_n940# VDD 0.15973f
C360 a_4458_n940# a_3896_n940# 0
C361 A0 a_713_n940# 0.0279f
C362 Sum2 B2 0
C363 a_1737_n940# a_2872_n940# 0
C364 Cin VDD 0.11056f
C365 Sum3 B3 0
C366 a_6008_n940# a_6764_n940# 0.08162f
C367 a_1737_n940# a_3370_n940# 0
C368 a_2512_n940# a_4605_n940# 0
C369 A0 Cin 0.0292f
C370 a_n209_n940# a_926_n940# 0
C371 a_4458_n940# a_6404_n940# 0.00186f
C372 a_3683_n940# a_2872_n940# 0
C373 B2 A2 0.25966f
C374 a_3683_n940# a_3370_n940# 0.14113f
C375 A0 VDD 0.14924f
C376 A1 a_2659_n940# 0.0279f
C377 A3 Sum3 0.02504f
C378 Sum0 a_n209_n940# 0
C379 a_5629_n940# B3 0.15454f
C380 Sum2 a_4062_n940# 0.1345f
C381 a_713_n940# A1 0
C382 B2 a_5316_n940# 0
C383 a_566_n940# a_1424_n940# 0.11435f
C384 a_4458_n940# a_6764_n940# 0
C385 A2 a_5842_n940# 0
C386 Cout B3 0
C387 A1 Cin 0
C388 a_3683_n940# a_4605_n940# 0.00667f
C389 a_6008_n940# B3 0.32061f
C390 B2 a_3896_n940# 0.10296f
C391 A3 a_5629_n940# 0.24827f
C392 A2 a_4062_n940# 0.48936f
C393 a_6551_n940# A2 0
C394 a_2659_n940# a_2116_n940# 0.29111f
C395 A1 VDD 0.15361f
C396 a_2872_n940# Sum1 0.1663f
C397 a_5316_n940# a_5842_n940# 0.03544f
C398 Cout GND 0.43388f
C399 Sum3 GND 1.20773f
C400 Sum2 GND 1.42279f
C401 Sum1 GND 0.3371f
C402 Sum0 GND 0.68597f
C403 VDD GND 21.79668f
C404 a_6764_n940# GND 1.81156f
C405 a_6404_n940# GND 0.27218f
C406 a_6008_n940# GND 0.1724f
C407 a_5842_n940# GND 1.05206f
C408 a_4818_n940# GND 1.83711f
C409 a_3896_n940# GND 0.57096f
C410 a_2872_n940# GND 1.31554f
C411 a_1950_n940# GND 0.45369f
C412 a_926_n940# GND 0.80666f
C413 a_170_n940# GND 0.38003f
C414 a_4_n940# GND 1.38994f
C415 a_3683_n940# GND 0.16085f
C416 a_1737_n940# GND 0.71117f
.ends
