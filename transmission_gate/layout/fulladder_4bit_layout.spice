* NGSPICE file created from fulladder_4bit.ext - technology: sky130A

.subckt fulladder_4bit A1 B1 A3 B3 A2 B2 Cin A0 B0 Cout Sum1 Sum3 Sum2 Sum0 GND VDD
X0 Sum1 a_2659_n940# a_2872_n940# VDD sky130_fd_pr__pfet_01v8 ad=0.4403 pd=1.975 as=0.4403 ps=1.975 w=1.295 l=0.15
X1 Sum3 a_6008_n940# a_6764_n940# GND sky130_fd_pr__nfet_01v8 ad=0.1428 pd=1.1 as=0.1428 ps=1.1 w=0.42 l=0.15
X2 a_3370_n940# a_4062_n940# Sum2 VDD sky130_fd_pr__pfet_01v8 ad=0.4403 pd=1.975 as=0.4403 ps=1.975 w=1.295 l=0.15
X3 a_566_n940# a_170_n940# VDD VDD sky130_fd_pr__pfet_01v8 ad=0.60217 pd=3.52 as=0.34317 ps=3.12 w=1.295 l=0.15
X4 VDD A3 a_5629_n940# VDD sky130_fd_pr__pfet_01v8 ad=0.28275 pd=2.185 as=0.87652 ps=4.7 w=1.885 l=0.15
X5 B1 a_1737_n940# a_2116_n940# GND sky130_fd_pr__nfet_01v8 ad=0.28365 pd=2.15 as=0.2074 ps=1.29 w=0.61 l=0.15
X6 Cin a_170_n940# Sum0 VDD sky130_fd_pr__pfet_01v8 ad=0.4403 pd=1.975 as=0.4403 ps=1.975 w=1.295 l=0.15
X7 VDD a_6008_n940# a_6551_n940# VDD sky130_fd_pr__pfet_01v8 ad=0.19425 pd=1.595 as=0.60217 ps=3.52 w=1.295 l=0.15
X8 a_1424_n940# a_2659_n940# Sum1 GND sky130_fd_pr__nfet_01v8 ad=0.1428 pd=1.1 as=0.1428 ps=1.1 w=0.42 l=0.15
X9 a_3370_n940# a_2512_n940# a_1424_n940# VDD sky130_fd_pr__pfet_01v8 ad=0.4403 pd=1.975 as=0.4403 ps=1.975 w=1.295 l=0.15
X10 a_5842_n940# B3 VDD VDD sky130_fd_pr__pfet_01v8 ad=0.6409 pd=2.565 as=0.28275 ps=2.185 w=1.885 l=0.15
X11 GND A2 a_3683_n940# GND sky130_fd_pr__nfet_01v8 ad=0.0915 pd=0.91 as=0.28365 ps=2.15 w=0.61 l=0.15
X12 a_6764_n940# a_5316_n940# VDD VDD sky130_fd_pr__pfet_01v8 ad=0.4403 pd=1.975 as=0.19425 ps=1.595 w=1.295 l=0.15
X13 GND a_4062_n940# a_4605_n940# GND sky130_fd_pr__nfet_01v8 ad=0.063 pd=0.72 as=0.1953 ps=1.77 w=0.42 l=0.15
X14 GND A0 a_n209_n940# GND sky130_fd_pr__nfet_01v8 ad=0.0915 pd=0.91 as=0.28365 ps=2.15 w=0.61 l=0.15
X15 a_1424_n940# a_170_n940# Cin GND sky130_fd_pr__nfet_01v8 ad=0.1428 pd=1.1 as=0.1428 ps=1.1 w=0.42 l=0.15
X16 a_3896_n940# B2 GND GND sky130_fd_pr__nfet_01v8 ad=0.2074 pd=1.29 as=0.0915 ps=0.91 w=0.61 l=0.15
X17 Cout a_6008_n940# a_5316_n940# GND sky130_fd_pr__nfet_01v8 ad=0.1428 pd=1.1 as=0.1428 ps=1.1 w=0.42 l=0.15
X18 VDD a_170_n940# a_713_n940# VDD sky130_fd_pr__pfet_01v8 ad=0.19425 pd=1.595 as=0.60217 ps=3.52 w=1.295 l=0.15
X19 A0 a_170_n940# a_1424_n940# VDD sky130_fd_pr__pfet_01v8 ad=0.60217 pd=3.52 as=0.4403 ps=1.975 w=1.295 l=0.15
X20 a_2116_n940# a_1737_n940# a_1950_n940# VDD sky130_fd_pr__pfet_01v8 ad=0.6409 pd=2.565 as=0.6409 ps=2.565 w=1.885 l=0.15
X21 A3 a_6008_n940# Cout VDD sky130_fd_pr__pfet_01v8 ad=0.60217 pd=3.52 as=0.4403 ps=1.975 w=1.295 l=0.15
X22 a_4818_n940# a_3370_n940# GND GND sky130_fd_pr__nfet_01v8 ad=0.1428 pd=1.1 as=0.063 ps=0.72 w=0.42 l=0.15
X23 a_170_n940# a_n209_n940# a_4_n940# VDD sky130_fd_pr__pfet_01v8 ad=0.6409 pd=2.565 as=0.6409 ps=2.565 w=1.885 l=0.15
X24 Sum2 a_4605_n940# a_4818_n940# VDD sky130_fd_pr__pfet_01v8 ad=0.4403 pd=1.975 as=0.4403 ps=1.975 w=1.295 l=0.15
X25 a_2512_n940# a_2116_n940# VDD VDD sky130_fd_pr__pfet_01v8 ad=0.60217 pd=3.52 as=0.34317 ps=3.12 w=1.295 l=0.15
X26 A1 a_2116_n940# a_3370_n940# VDD sky130_fd_pr__pfet_01v8 ad=0.60217 pd=3.52 as=0.4403 ps=1.975 w=1.295 l=0.15
X27 B3 A3 a_6008_n940# VDD sky130_fd_pr__pfet_01v8 ad=0.87652 pd=4.7 as=0.6409 ps=2.565 w=1.885 l=0.15
X28 A2 a_4458_n940# a_5316_n940# GND sky130_fd_pr__nfet_01v8 ad=0.1953 pd=1.77 as=0.1428 ps=1.1 w=0.42 l=0.15
X29 a_4458_n940# a_4062_n940# VDD VDD sky130_fd_pr__pfet_01v8 ad=0.60217 pd=3.52 as=0.34317 ps=3.12 w=1.295 l=0.15
X30 Sum0 a_170_n940# a_926_n940# GND sky130_fd_pr__nfet_01v8 ad=0.1428 pd=1.1 as=0.1428 ps=1.1 w=0.42 l=0.15
X31 a_6404_n940# a_6008_n940# GND GND sky130_fd_pr__nfet_01v8 ad=0.1953 pd=1.77 as=0.1113 ps=1.37 w=0.42 l=0.15
X32 a_5316_n940# a_6008_n940# Sum3 VDD sky130_fd_pr__pfet_01v8 ad=0.4403 pd=1.975 as=0.4403 ps=1.975 w=1.295 l=0.15
X33 B2 a_3683_n940# a_4062_n940# GND sky130_fd_pr__nfet_01v8 ad=0.28365 pd=2.15 as=0.2074 ps=1.29 w=0.61 l=0.15
X34 VDD A1 a_1737_n940# VDD sky130_fd_pr__pfet_01v8 ad=0.28275 pd=2.185 as=0.87652 ps=4.7 w=1.885 l=0.15
X35 Sum1 a_2116_n940# a_2872_n940# GND sky130_fd_pr__nfet_01v8 ad=0.1428 pd=1.1 as=0.1428 ps=1.1 w=0.42 l=0.15
X36 B0 A0 a_170_n940# VDD sky130_fd_pr__pfet_01v8 ad=0.87652 pd=4.7 as=0.6409 ps=2.565 w=1.885 l=0.15
X37 a_1950_n940# B1 VDD VDD sky130_fd_pr__pfet_01v8 ad=0.6409 pd=2.565 as=0.28275 ps=2.185 w=1.885 l=0.15
X38 VDD a_2116_n940# a_2659_n940# VDD sky130_fd_pr__pfet_01v8 ad=0.19425 pd=1.595 as=0.60217 ps=3.52 w=1.295 l=0.15
X39 a_566_n940# a_170_n940# GND GND sky130_fd_pr__nfet_01v8 ad=0.1953 pd=1.77 as=0.1113 ps=1.37 w=0.42 l=0.15
X40 a_3370_n940# a_4605_n940# Sum2 GND sky130_fd_pr__nfet_01v8 ad=0.1428 pd=1.1 as=0.1428 ps=1.1 w=0.42 l=0.15
X41 a_5316_n940# a_4458_n940# a_3370_n940# VDD sky130_fd_pr__pfet_01v8 ad=0.4403 pd=1.975 as=0.4403 ps=1.975 w=1.295 l=0.15
X42 GND A3 a_5629_n940# GND sky130_fd_pr__nfet_01v8 ad=0.0915 pd=0.91 as=0.28365 ps=2.15 w=0.61 l=0.15
X43 a_2872_n940# a_1424_n940# VDD VDD sky130_fd_pr__pfet_01v8 ad=0.4403 pd=1.975 as=0.19425 ps=1.595 w=1.295 l=0.15
X44 Cin a_713_n940# Sum0 GND sky130_fd_pr__nfet_01v8 ad=0.1428 pd=1.1 as=0.1428 ps=1.1 w=0.42 l=0.15
X45 GND a_6008_n940# a_6551_n940# GND sky130_fd_pr__nfet_01v8 ad=0.063 pd=0.72 as=0.1953 ps=1.77 w=0.42 l=0.15
X46 a_4_n940# B0 VDD VDD sky130_fd_pr__pfet_01v8 ad=0.6409 pd=2.565 as=0.28275 ps=2.185 w=1.885 l=0.15
X47 a_926_n940# Cin VDD VDD sky130_fd_pr__pfet_01v8 ad=0.4403 pd=1.975 as=0.19425 ps=1.595 w=1.295 l=0.15
X48 a_6008_n940# a_5629_n940# a_5842_n940# VDD sky130_fd_pr__pfet_01v8 ad=0.6409 pd=2.565 as=0.6409 ps=2.565 w=1.885 l=0.15
X49 a_3370_n940# a_2116_n940# a_1424_n940# GND sky130_fd_pr__nfet_01v8 ad=0.1428 pd=1.1 as=0.1428 ps=1.1 w=0.42 l=0.15
X50 a_5842_n940# B3 GND GND sky130_fd_pr__nfet_01v8 ad=0.2074 pd=1.29 as=0.0915 ps=0.91 w=0.61 l=0.15
X51 a_4062_n940# a_3683_n940# a_3896_n940# VDD sky130_fd_pr__pfet_01v8 ad=0.6409 pd=2.565 as=0.6409 ps=2.565 w=1.885 l=0.15
X52 a_6764_n940# a_5316_n940# GND GND sky130_fd_pr__nfet_01v8 ad=0.1428 pd=1.1 as=0.063 ps=0.72 w=0.42 l=0.15
X53 Sum3 a_6551_n940# a_6764_n940# VDD sky130_fd_pr__pfet_01v8 ad=0.4403 pd=1.975 as=0.4403 ps=1.975 w=1.295 l=0.15
X54 GND a_170_n940# a_713_n940# GND sky130_fd_pr__nfet_01v8 ad=0.063 pd=0.72 as=0.1953 ps=1.77 w=0.42 l=0.15
X55 A0 a_566_n940# a_1424_n940# GND sky130_fd_pr__nfet_01v8 ad=0.1953 pd=1.77 as=0.1428 ps=1.1 w=0.42 l=0.15
X56 a_2116_n940# A1 a_1950_n940# GND sky130_fd_pr__nfet_01v8 ad=0.2074 pd=1.29 as=0.2074 ps=1.29 w=0.61 l=0.15
X57 A3 a_6404_n940# Cout GND sky130_fd_pr__nfet_01v8 ad=0.1953 pd=1.77 as=0.1428 ps=1.1 w=0.42 l=0.15
X58 B1 A1 a_2116_n940# VDD sky130_fd_pr__pfet_01v8 ad=0.87652 pd=4.7 as=0.6409 ps=2.565 w=1.885 l=0.15
X59 a_170_n940# A0 a_4_n940# GND sky130_fd_pr__nfet_01v8 ad=0.2074 pd=1.29 as=0.2074 ps=1.29 w=0.61 l=0.15
X60 Sum2 a_4062_n940# a_4818_n940# GND sky130_fd_pr__nfet_01v8 ad=0.1428 pd=1.1 as=0.1428 ps=1.1 w=0.42 l=0.15
X61 a_1424_n940# a_2116_n940# Sum1 VDD sky130_fd_pr__pfet_01v8 ad=0.4403 pd=1.975 as=0.4403 ps=1.975 w=1.295 l=0.15
X62 a_2512_n940# a_2116_n940# GND GND sky130_fd_pr__nfet_01v8 ad=0.1953 pd=1.77 as=0.1113 ps=1.37 w=0.42 l=0.15
X63 VDD A2 a_3683_n940# VDD sky130_fd_pr__pfet_01v8 ad=0.28275 pd=2.185 as=0.87652 ps=4.7 w=1.885 l=0.15
X64 A1 a_2512_n940# a_3370_n940# GND sky130_fd_pr__nfet_01v8 ad=0.1953 pd=1.77 as=0.1428 ps=1.1 w=0.42 l=0.15
X65 B3 a_5629_n940# a_6008_n940# GND sky130_fd_pr__nfet_01v8 ad=0.28365 pd=2.15 as=0.2074 ps=1.29 w=0.61 l=0.15
X66 a_4458_n940# a_4062_n940# GND GND sky130_fd_pr__nfet_01v8 ad=0.1953 pd=1.77 as=0.1113 ps=1.37 w=0.42 l=0.15
X67 VDD A0 a_n209_n940# VDD sky130_fd_pr__pfet_01v8 ad=0.28275 pd=2.185 as=0.87652 ps=4.7 w=1.885 l=0.15
X68 a_1424_n940# a_566_n940# Cin VDD sky130_fd_pr__pfet_01v8 ad=0.4403 pd=1.975 as=0.4403 ps=1.975 w=1.295 l=0.15
X69 a_3896_n940# B2 VDD VDD sky130_fd_pr__pfet_01v8 ad=0.6409 pd=2.565 as=0.28275 ps=2.185 w=1.885 l=0.15
X70 VDD a_4062_n940# a_4605_n940# VDD sky130_fd_pr__pfet_01v8 ad=0.19425 pd=1.595 as=0.60217 ps=3.52 w=1.295 l=0.15
X71 Cout a_6404_n940# a_5316_n940# VDD sky130_fd_pr__pfet_01v8 ad=0.4403 pd=1.975 as=0.4403 ps=1.975 w=1.295 l=0.15
X72 a_5316_n940# a_6551_n940# Sum3 GND sky130_fd_pr__nfet_01v8 ad=0.1428 pd=1.1 as=0.1428 ps=1.1 w=0.42 l=0.15
X73 a_4818_n940# a_3370_n940# VDD VDD sky130_fd_pr__pfet_01v8 ad=0.4403 pd=1.975 as=0.19425 ps=1.595 w=1.295 l=0.15
X74 GND A1 a_1737_n940# GND sky130_fd_pr__nfet_01v8 ad=0.0915 pd=0.91 as=0.28365 ps=2.15 w=0.61 l=0.15
X75 B0 a_n209_n940# a_170_n940# GND sky130_fd_pr__nfet_01v8 ad=0.28365 pd=2.15 as=0.2074 ps=1.29 w=0.61 l=0.15
X76 a_1950_n940# B1 GND GND sky130_fd_pr__nfet_01v8 ad=0.2074 pd=1.29 as=0.0915 ps=0.91 w=0.61 l=0.15
X77 GND a_2116_n940# a_2659_n940# GND sky130_fd_pr__nfet_01v8 ad=0.063 pd=0.72 as=0.1953 ps=1.77 w=0.42 l=0.15
X78 a_5316_n940# a_4062_n940# a_3370_n940# GND sky130_fd_pr__nfet_01v8 ad=0.1428 pd=1.1 as=0.1428 ps=1.1 w=0.42 l=0.15
X79 A2 a_4062_n940# a_5316_n940# VDD sky130_fd_pr__pfet_01v8 ad=0.60217 pd=3.52 as=0.4403 ps=1.975 w=1.295 l=0.15
X80 a_2872_n940# a_1424_n940# GND GND sky130_fd_pr__nfet_01v8 ad=0.1428 pd=1.1 as=0.063 ps=0.72 w=0.42 l=0.15
X81 Sum0 a_713_n940# a_926_n940# VDD sky130_fd_pr__pfet_01v8 ad=0.4403 pd=1.975 as=0.4403 ps=1.975 w=1.295 l=0.15
X82 a_6404_n940# a_6008_n940# VDD VDD sky130_fd_pr__pfet_01v8 ad=0.60217 pd=3.52 as=0.34317 ps=3.12 w=1.295 l=0.15
X83 a_4_n940# B0 GND GND sky130_fd_pr__nfet_01v8 ad=0.2074 pd=1.29 as=0.0915 ps=0.91 w=0.61 l=0.15
X84 a_926_n940# Cin GND GND sky130_fd_pr__nfet_01v8 ad=0.1428 pd=1.1 as=0.063 ps=0.72 w=0.42 l=0.15
X85 a_6008_n940# A3 a_5842_n940# GND sky130_fd_pr__nfet_01v8 ad=0.2074 pd=1.29 as=0.2074 ps=1.29 w=0.61 l=0.15
X86 B2 A2 a_4062_n940# VDD sky130_fd_pr__pfet_01v8 ad=0.87652 pd=4.7 as=0.6409 ps=2.565 w=1.885 l=0.15
X87 a_4062_n940# A2 a_3896_n940# GND sky130_fd_pr__nfet_01v8 ad=0.2074 pd=1.29 as=0.2074 ps=1.29 w=0.61 l=0.15
.ends
