* NGSPICE file created from fulladder.ext - technology: sky130A

.subckt fulladder Cin A B Sum Cout GND VDD
X0 GND a_170_n850# a_483_n895# GND sky130_fd_pr__nfet_01v8 ad=0.12705 pd=1.18 as=0.3906 ps=2.61 w=0.84 l=0.15
X1 Cin a_483_n895# Sum GND sky130_fd_pr__nfet_01v8 ad=0.1428 pd=1.1 as=0.1428 ps=1.1 w=0.42 l=0.15
X2 a_704_n850# Cin VDD VDD sky130_fd_pr__pfet_01v8 ad=0.4403 pd=1.975 as=0.39173 ps=2.93 w=1.295 l=0.15
X3 GND A a_n209_n850# GND sky130_fd_pr__nfet_01v8 ad=0.0915 pd=0.91 as=0.28365 ps=2.15 w=0.61 l=0.15
X4 a_170_n850# a_n209_n850# a_4_n850# VDD sky130_fd_pr__pfet_01v8 ad=0.6409 pd=2.565 as=0.6409 ps=2.565 w=1.885 l=0.15
X5 Cout a_483_n895# Cin VDD sky130_fd_pr__pfet_01v8 ad=0.4403 pd=1.975 as=0.4403 ps=1.975 w=1.295 l=0.15
X6 B A a_170_n850# VDD sky130_fd_pr__pfet_01v8 ad=0.87652 pd=4.7 as=0.6409 ps=2.565 w=1.885 l=0.15
X7 a_4_n850# B VDD VDD sky130_fd_pr__pfet_01v8 ad=0.6409 pd=2.565 as=0.28275 ps=2.185 w=1.885 l=0.15
X8 a_704_n850# Cin GND GND sky130_fd_pr__nfet_01v8 ad=0.1428 pd=1.1 as=0.12705 ps=1.18 w=0.42 l=0.15
X9 Sum a_483_n895# a_704_n850# VDD sky130_fd_pr__pfet_01v8 ad=0.4403 pd=1.975 as=0.4403 ps=1.975 w=1.295 l=0.15
X10 A a_170_n850# Cout VDD sky130_fd_pr__pfet_01v8 ad=0.60217 pd=3.52 as=0.4403 ps=1.975 w=1.295 l=0.15
X11 a_170_n850# A a_4_n850# GND sky130_fd_pr__nfet_01v8 ad=0.2074 pd=1.29 as=0.2074 ps=1.29 w=0.61 l=0.15
X12 Cin a_170_n850# Sum VDD sky130_fd_pr__pfet_01v8 ad=0.4403 pd=1.975 as=0.4403 ps=1.975 w=1.295 l=0.15
X13 VDD A a_n209_n850# VDD sky130_fd_pr__pfet_01v8 ad=0.28275 pd=2.185 as=0.87652 ps=4.7 w=1.885 l=0.15
X14 Cout a_170_n850# Cin GND sky130_fd_pr__nfet_01v8 ad=0.1428 pd=1.1 as=0.1428 ps=1.1 w=0.42 l=0.15
X15 VDD a_170_n850# a_483_n895# VDD sky130_fd_pr__pfet_01v8 ad=0.39173 pd=2.93 as=1.20435 ps=6.11 w=2.59 l=0.15
X16 B a_n209_n850# a_170_n850# GND sky130_fd_pr__nfet_01v8 ad=0.28365 pd=2.15 as=0.2074 ps=1.29 w=0.61 l=0.15
X17 a_4_n850# B GND GND sky130_fd_pr__nfet_01v8 ad=0.2074 pd=1.29 as=0.0915 ps=0.91 w=0.61 l=0.15
X18 Sum a_170_n850# a_704_n850# GND sky130_fd_pr__nfet_01v8 ad=0.1428 pd=1.1 as=0.1428 ps=1.1 w=0.42 l=0.15
X19 A a_483_n895# Cout GND sky130_fd_pr__nfet_01v8 ad=0.1953 pd=1.77 as=0.1428 ps=1.1 w=0.42 l=0.15
.ends
