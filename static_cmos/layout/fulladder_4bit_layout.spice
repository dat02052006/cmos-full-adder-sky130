* NGSPICE file created from fulladder_4bit.ext - technology: sky130A

.subckt fulladder_4bit A1 B1 B3 A3 B2 A2 A0 B0 Cin Sum1 Sum3 Cout Sum2 Sum0 GND VDD
X0 a_8616_n67# a_7234_n844# a_8616_n768# GND sky130_fd_pr__nfet_01v8 ad=0.21465 pd=2.15 as=0.19845 ps=1.3 w=0.81 l=0.15
X1 VDD B0 a_106_n774# VDD sky130_fd_pr__pfet_01v8 ad=0.20458 pd=1.635 as=0.45325 ps=1.995 w=1.295 l=0.15
X2 a_3649_n720# a_3021_n774# VDD VDD sky130_fd_pr__pfet_01v8 ad=0.308 pd=1.58 as=0.2332 ps=2.29 w=0.88 l=0.15
X3 a_6287_n67# A2 a_6287_n720# GND sky130_fd_pr__nfet_01v8 ad=0.27075 pd=2.09 as=0.13965 ps=1.06 w=0.57 l=0.15
X4 VDD a_457_n67# a_1127_n67# VDD sky130_fd_pr__pfet_01v8 ad=0.47567 pd=4.12 as=0.62825 ps=2.495 w=1.795 l=0.15
X5 a_4714_n67# a_4319_n844# VDD VDD sky130_fd_pr__pfet_01v8 ad=0.43575 pd=1.945 as=0.28915 ps=2.17 w=1.245 l=0.15
X6 VDD a_1127_n67# a_1799_n67# VDD sky130_fd_pr__pfet_01v8 ad=0.32993 pd=3.02 as=0.43575 ps=1.945 w=1.245 l=0.15
X7 a_6287_n67# a_5936_n774# VDD VDD sky130_fd_pr__pfet_01v8 ad=0.2156 pd=1.37 as=0.20458 ps=1.635 w=0.88 l=0.15
X8 VDD A3 a_9202_n67# VDD sky130_fd_pr__pfet_01v8 ad=0.2332 pd=2.29 as=0.2156 ps=1.37 w=0.88 l=0.15
X9 a_7946_n768# a_7234_n844# VDD VDD sky130_fd_pr__pfet_01v8 ad=0.30812 pd=1.74 as=0.32993 ps=3.02 w=1.245 l=0.15
X10 VDD a_7629_n67# Sum2 VDD sky130_fd_pr__pfet_01v8 ad=0.6731 pd=5.61 as=0.889 ps=3.24 w=2.54 l=0.15
X11 a_11531_n768# a_8851_n774# GND GND sky130_fd_pr__nfet_01v8 ad=0.19845 pd=1.3 as=0.21465 ps=2.15 w=0.81 l=0.15
X12 GND B1 a_3104_n774# GND sky130_fd_pr__nfet_01v8 ad=0.13268 pd=1.18 as=0.294 ps=1.54 w=0.84 l=0.15
X13 a_10544_n768# a_10149_n844# GND GND sky130_fd_pr__nfet_01v8 ad=0.2835 pd=1.51 as=0.18805 ps=1.53 w=0.81 l=0.15
X14 a_1127_n839# a_734_n720# GND GND sky130_fd_pr__nfet_01v8 ad=0.40775 pd=1.865 as=0.17572 ps=1.505 w=1.165 l=0.15
X15 VDD a_5701_n67# a_7234_n844# VDD sky130_fd_pr__pfet_01v8 ad=0.28915 pd=2.17 as=0.6405 ps=2.53 w=1.83 l=0.15
X16 GND a_5701_n67# a_8029_n768# GND sky130_fd_pr__nfet_01v8 ad=0.24833 pd=1.985 as=0.20048 ps=1.305 w=0.81 l=0.15
X17 a_1531_n844# a_1127_n67# a_1404_n844# GND sky130_fd_pr__nfet_01v8 ad=0.4165 pd=1.89 as=0.57715 ps=3.35 w=1.19 l=0.15
X18 Cout a_8851_n774# VDD VDD sky130_fd_pr__pfet_01v8 ad=0.30503 pd=1.735 as=0.32993 ps=3.02 w=1.245 l=0.15
X19 VDD a_4319_n844# a_5701_n67# VDD sky130_fd_pr__pfet_01v8 ad=0.32993 pd=3.02 as=0.30503 ps=1.735 w=1.245 l=0.15
X20 a_10944_n768# a_10149_n844# a_10861_n768# GND sky130_fd_pr__nfet_01v8 ad=0.20048 pd=1.305 as=0.21465 ps=2.15 w=0.81 l=0.15
X21 a_8934_n774# A3 a_8851_n774# GND sky130_fd_pr__nfet_01v8 ad=0.294 pd=1.54 as=0.2226 ps=2.21 w=0.84 l=0.15
X22 GND B0 a_859_n720# GND sky130_fd_pr__nfet_01v8 ad=0.17572 pd=1.505 as=0.1995 ps=1.27 w=0.57 l=0.15
X23 a_10149_n844# a_9872_n67# VDD VDD sky130_fd_pr__pfet_01v8 ad=0.6405 pd=2.53 as=0.86925 ps=4.61 w=1.83 l=0.15
X24 a_11171_n935# a_10861_n768# GND GND sky130_fd_pr__nfet_01v8 ad=0.57575 pd=2.345 as=0.24833 ps=1.985 w=1.645 l=0.15
X25 GND B3 a_8934_n774# GND sky130_fd_pr__nfet_01v8 ad=0.13268 pd=1.18 as=0.294 ps=1.54 w=0.84 l=0.15
X26 a_6689_n720# a_5936_n774# a_6564_n720# GND sky130_fd_pr__nfet_01v8 ad=0.1995 pd=1.27 as=0.27075 ps=2.09 w=0.57 l=0.15
X27 Sum2 a_7946_n768# VDD VDD sky130_fd_pr__pfet_01v8 ad=0.889 pd=3.24 as=0.38322 ps=2.88 w=2.54 l=0.15
X28 a_7361_n844# a_6957_n67# a_7234_n844# GND sky130_fd_pr__nfet_01v8 ad=0.4165 pd=1.89 as=0.57715 ps=3.35 w=1.19 l=0.15
X29 GND B1 a_3774_n720# GND sky130_fd_pr__nfet_01v8 ad=0.17572 pd=1.505 as=0.1995 ps=1.27 w=0.57 l=0.15
X30 VDD Cin a_2116_n768# VDD sky130_fd_pr__pfet_01v8 ad=0.38322 pd=2.88 as=0.30812 ps=1.74 w=1.245 l=0.15
X31 VDD B1 a_3649_n720# VDD sky130_fd_pr__pfet_01v8 ad=0.27082 pd=2.135 as=0.308 ps=1.58 w=0.88 l=0.15
X32 VDD a_3372_n67# a_4042_n67# VDD sky130_fd_pr__pfet_01v8 ad=0.47567 pd=4.12 as=0.62825 ps=2.495 w=1.795 l=0.15
X33 GND a_2786_n67# a_4446_n844# GND sky130_fd_pr__nfet_01v8 ad=0.18805 pd=1.53 as=0.4165 ps=1.89 w=1.19 l=0.15
X34 a_4042_n67# a_3372_n67# a_4042_n839# GND sky130_fd_pr__nfet_01v8 ad=0.30872 pd=2.86 as=0.40775 ps=1.865 w=1.165 l=0.15
X35 Cout a_10149_n844# a_11531_n768# GND sky130_fd_pr__nfet_01v8 ad=0.21465 pd=2.15 as=0.19845 ps=1.3 w=0.81 l=0.15
X36 a_2786_n67# a_1404_n844# a_2786_n768# GND sky130_fd_pr__nfet_01v8 ad=0.21465 pd=2.15 as=0.19845 ps=1.3 w=0.81 l=0.15
X37 VDD a_4042_n67# a_4714_n67# VDD sky130_fd_pr__pfet_01v8 ad=0.32993 pd=3.02 as=0.43575 ps=1.945 w=1.245 l=0.15
X38 GND B3 a_9604_n720# GND sky130_fd_pr__nfet_01v8 ad=0.17572 pd=1.505 as=0.1995 ps=1.27 w=0.57 l=0.15
X39 a_6564_n720# a_5936_n774# VDD VDD sky130_fd_pr__pfet_01v8 ad=0.308 pd=1.58 as=0.2332 ps=2.29 w=0.88 l=0.15
X40 a_9872_n839# a_9479_n720# GND GND sky130_fd_pr__nfet_01v8 ad=0.40775 pd=1.865 as=0.17572 ps=1.505 w=1.165 l=0.15
X41 a_2199_n768# a_1404_n844# a_2116_n768# GND sky130_fd_pr__nfet_01v8 ad=0.20048 pd=1.305 as=0.21465 ps=2.15 w=0.81 l=0.15
X42 a_8851_n774# A3 VDD VDD sky130_fd_pr__pfet_01v8 ad=0.45325 pd=1.995 as=0.34317 ps=3.12 w=1.295 l=0.15
X43 a_9202_n67# a_8851_n774# VDD VDD sky130_fd_pr__pfet_01v8 ad=0.2156 pd=1.37 as=0.20458 ps=1.635 w=0.88 l=0.15
X44 a_3372_n720# a_3021_n774# GND GND sky130_fd_pr__nfet_01v8 ad=0.13965 pd=1.06 as=0.13268 ps=1.18 w=0.57 l=0.15
X45 a_7629_n67# a_7234_n844# VDD VDD sky130_fd_pr__pfet_01v8 ad=0.43575 pd=1.945 as=0.28915 ps=2.17 w=1.245 l=0.15
X46 a_1799_n67# a_1127_n67# a_1799_n768# GND sky130_fd_pr__nfet_01v8 ad=0.37665 pd=2.55 as=0.2835 ps=1.51 w=0.81 l=0.15
X47 a_4042_n67# a_3649_n720# VDD VDD sky130_fd_pr__pfet_01v8 ad=0.62825 pd=2.495 as=0.27082 ps=2.135 w=1.795 l=0.15
X48 a_9202_n720# a_8851_n774# GND GND sky130_fd_pr__nfet_01v8 ad=0.13965 pd=1.06 as=0.13268 ps=1.18 w=0.57 l=0.15
X49 a_5341_n935# a_5031_n768# GND GND sky130_fd_pr__nfet_01v8 ad=0.57575 pd=2.345 as=0.24833 ps=1.985 w=1.645 l=0.15
X50 Sum0 a_1799_n67# a_2426_n935# GND sky130_fd_pr__nfet_01v8 ad=0.43593 pd=3.82 as=0.57575 ps=2.345 w=1.645 l=0.15
X51 Sum3 a_10861_n768# VDD VDD sky130_fd_pr__pfet_01v8 ad=0.889 pd=3.24 as=0.38322 ps=2.88 w=2.54 l=0.15
X52 a_7629_n67# a_6957_n67# a_7629_n768# GND sky130_fd_pr__nfet_01v8 ad=0.37665 pd=2.55 as=0.2835 ps=1.51 w=0.81 l=0.15
X53 VDD a_8616_n67# a_10149_n844# VDD sky130_fd_pr__pfet_01v8 ad=0.28915 pd=2.17 as=0.6405 ps=2.53 w=1.83 l=0.15
X54 GND Cin a_2199_n768# GND sky130_fd_pr__nfet_01v8 ad=0.24833 pd=1.985 as=0.20048 ps=1.305 w=0.81 l=0.15
X55 a_457_n67# A0 a_457_n720# GND sky130_fd_pr__nfet_01v8 ad=0.27075 pd=2.09 as=0.13965 ps=1.06 w=0.57 l=0.15
X56 a_3021_n774# A1 VDD VDD sky130_fd_pr__pfet_01v8 ad=0.45325 pd=1.995 as=0.34317 ps=3.12 w=1.295 l=0.15
X57 Sum2 a_7629_n67# a_8256_n935# GND sky130_fd_pr__nfet_01v8 ad=0.43593 pd=3.82 as=0.57575 ps=2.345 w=1.645 l=0.15
X58 a_457_n67# a_106_n774# VDD VDD sky130_fd_pr__pfet_01v8 ad=0.2156 pd=1.37 as=0.20458 ps=1.635 w=0.88 l=0.15
X59 a_2786_n67# a_106_n774# VDD VDD sky130_fd_pr__pfet_01v8 ad=0.30503 pd=1.735 as=0.32993 ps=3.02 w=1.245 l=0.15
X60 a_10276_n844# a_9872_n67# a_10149_n844# GND sky130_fd_pr__nfet_01v8 ad=0.4165 pd=1.89 as=0.57715 ps=3.35 w=1.19 l=0.15
X61 VDD B2 a_6564_n720# VDD sky130_fd_pr__pfet_01v8 ad=0.27082 pd=2.135 as=0.308 ps=1.58 w=0.88 l=0.15
X62 a_9479_n720# a_8851_n774# VDD VDD sky130_fd_pr__pfet_01v8 ad=0.308 pd=1.58 as=0.2332 ps=2.29 w=0.88 l=0.15
X63 VDD a_6287_n67# a_6957_n67# VDD sky130_fd_pr__pfet_01v8 ad=0.47567 pd=4.12 as=0.62825 ps=2.495 w=1.795 l=0.15
X64 a_189_n774# A0 a_106_n774# GND sky130_fd_pr__nfet_01v8 ad=0.294 pd=1.54 as=0.2226 ps=2.21 w=0.84 l=0.15
X65 a_9202_n67# A3 a_9202_n720# GND sky130_fd_pr__nfet_01v8 ad=0.27075 pd=2.09 as=0.13965 ps=1.06 w=0.57 l=0.15
X66 VDD B0 a_734_n720# VDD sky130_fd_pr__pfet_01v8 ad=0.27082 pd=2.135 as=0.308 ps=1.58 w=0.88 l=0.15
X67 VDD a_6957_n67# a_7629_n67# VDD sky130_fd_pr__pfet_01v8 ad=0.32993 pd=3.02 as=0.43575 ps=1.945 w=1.245 l=0.15
X68 a_2116_n768# a_1404_n844# VDD VDD sky130_fd_pr__pfet_01v8 ad=0.30812 pd=1.74 as=0.32993 ps=3.02 w=1.245 l=0.15
X69 VDD A1 a_3372_n67# VDD sky130_fd_pr__pfet_01v8 ad=0.2332 pd=2.29 as=0.2156 ps=1.37 w=0.88 l=0.15
X70 a_10861_n768# a_10149_n844# VDD VDD sky130_fd_pr__pfet_01v8 ad=0.30812 pd=1.74 as=0.32993 ps=3.02 w=1.245 l=0.15
X71 VDD a_10544_n67# Sum3 VDD sky130_fd_pr__pfet_01v8 ad=0.6731 pd=5.61 as=0.889 ps=3.24 w=2.54 l=0.15
X72 a_5701_n768# a_3021_n774# GND GND sky130_fd_pr__nfet_01v8 ad=0.19845 pd=1.3 as=0.21465 ps=2.15 w=0.81 l=0.15
X73 a_859_n720# a_106_n774# a_734_n720# GND sky130_fd_pr__nfet_01v8 ad=0.1995 pd=1.27 as=0.27075 ps=2.09 w=0.57 l=0.15
X74 GND B2 a_6019_n774# GND sky130_fd_pr__nfet_01v8 ad=0.13268 pd=1.18 as=0.294 ps=1.54 w=0.84 l=0.15
X75 VDD Cin a_1404_n844# VDD sky130_fd_pr__pfet_01v8 ad=0.28915 pd=2.17 as=0.6405 ps=2.53 w=1.83 l=0.15
X76 a_4714_n768# a_4319_n844# GND GND sky130_fd_pr__nfet_01v8 ad=0.2835 pd=1.51 as=0.18805 ps=1.53 w=0.81 l=0.15
X77 a_734_n720# a_106_n774# VDD VDD sky130_fd_pr__pfet_01v8 ad=0.308 pd=1.58 as=0.2332 ps=2.29 w=0.88 l=0.15
X78 VDD B1 a_3021_n774# VDD sky130_fd_pr__pfet_01v8 ad=0.20458 pd=1.635 as=0.45325 ps=1.995 w=1.295 l=0.15
X79 a_4446_n844# a_4042_n67# a_4319_n844# GND sky130_fd_pr__nfet_01v8 ad=0.4165 pd=1.89 as=0.57715 ps=3.35 w=1.19 l=0.15
X80 a_4042_n839# a_3649_n720# GND GND sky130_fd_pr__nfet_01v8 ad=0.40775 pd=1.865 as=0.17572 ps=1.505 w=1.165 l=0.15
X81 Sum0 a_2116_n768# VDD VDD sky130_fd_pr__pfet_01v8 ad=0.889 pd=3.24 as=0.38322 ps=2.88 w=2.54 l=0.15
X82 a_5701_n67# a_3021_n774# VDD VDD sky130_fd_pr__pfet_01v8 ad=0.30503 pd=1.735 as=0.32993 ps=3.02 w=1.245 l=0.15
X83 a_1127_n67# a_457_n67# a_1127_n839# GND sky130_fd_pr__nfet_01v8 ad=0.30872 pd=2.86 as=0.40775 ps=1.865 w=1.165 l=0.15
X84 Sum3 a_10544_n67# a_11171_n935# GND sky130_fd_pr__nfet_01v8 ad=0.43593 pd=3.82 as=0.57575 ps=2.345 w=1.645 l=0.15
X85 VDD a_9872_n67# a_10544_n67# VDD sky130_fd_pr__pfet_01v8 ad=0.32993 pd=3.02 as=0.43575 ps=1.945 w=1.245 l=0.15
X86 VDD B3 a_9479_n720# VDD sky130_fd_pr__pfet_01v8 ad=0.27082 pd=2.135 as=0.308 ps=1.58 w=0.88 l=0.15
X87 GND B2 a_6689_n720# GND sky130_fd_pr__nfet_01v8 ad=0.17572 pd=1.505 as=0.1995 ps=1.27 w=0.57 l=0.15
X88 VDD a_7234_n844# a_8616_n67# VDD sky130_fd_pr__pfet_01v8 ad=0.32993 pd=3.02 as=0.30503 ps=1.735 w=1.245 l=0.15
X89 a_6957_n67# a_6287_n67# a_6957_n839# GND sky130_fd_pr__nfet_01v8 ad=0.30872 pd=2.86 as=0.40775 ps=1.865 w=1.165 l=0.15
X90 a_6957_n839# a_6564_n720# GND GND sky130_fd_pr__nfet_01v8 ad=0.40775 pd=1.865 as=0.17572 ps=1.505 w=1.165 l=0.15
X91 GND a_5701_n67# a_7361_n844# GND sky130_fd_pr__nfet_01v8 ad=0.18805 pd=1.53 as=0.4165 ps=1.89 w=1.19 l=0.15
X92 a_1404_n844# a_1127_n67# VDD VDD sky130_fd_pr__pfet_01v8 ad=0.6405 pd=2.53 as=0.86925 ps=4.61 w=1.83 l=0.15
X93 GND a_8616_n67# a_10944_n768# GND sky130_fd_pr__nfet_01v8 ad=0.24833 pd=1.985 as=0.20048 ps=1.305 w=0.81 l=0.15
X94 a_5701_n67# a_4319_n844# a_5701_n768# GND sky130_fd_pr__nfet_01v8 ad=0.21465 pd=2.15 as=0.19845 ps=1.3 w=0.81 l=0.15
X95 a_5031_n768# a_4319_n844# VDD VDD sky130_fd_pr__pfet_01v8 ad=0.30812 pd=1.74 as=0.32993 ps=3.02 w=1.245 l=0.15
X96 VDD a_2786_n67# a_5031_n768# VDD sky130_fd_pr__pfet_01v8 ad=0.38322 pd=2.88 as=0.30812 ps=1.74 w=1.245 l=0.15
X97 a_3372_n67# A1 a_3372_n720# GND sky130_fd_pr__nfet_01v8 ad=0.27075 pd=2.09 as=0.13965 ps=1.06 w=0.57 l=0.15
X98 VDD A2 a_6287_n67# VDD sky130_fd_pr__pfet_01v8 ad=0.2332 pd=2.29 as=0.2156 ps=1.37 w=0.88 l=0.15
X99 a_6287_n720# a_5936_n774# GND GND sky130_fd_pr__nfet_01v8 ad=0.13965 pd=1.06 as=0.13268 ps=1.18 w=0.57 l=0.15
X100 a_10544_n67# a_10149_n844# VDD VDD sky130_fd_pr__pfet_01v8 ad=0.43575 pd=1.945 as=0.28915 ps=2.17 w=1.245 l=0.15
X101 a_8256_n935# a_7946_n768# GND GND sky130_fd_pr__nfet_01v8 ad=0.57575 pd=2.345 as=0.24833 ps=1.985 w=1.645 l=0.15
X102 a_3104_n774# A1 a_3021_n774# GND sky130_fd_pr__nfet_01v8 ad=0.294 pd=1.54 as=0.2226 ps=2.21 w=0.84 l=0.15
X103 VDD a_1799_n67# Sum0 VDD sky130_fd_pr__pfet_01v8 ad=0.6731 pd=5.61 as=0.889 ps=3.24 w=2.54 l=0.15
X104 VDD a_2786_n67# a_4319_n844# VDD sky130_fd_pr__pfet_01v8 ad=0.28915 pd=2.17 as=0.6405 ps=2.53 w=1.83 l=0.15
X105 VDD B2 a_5936_n774# VDD sky130_fd_pr__pfet_01v8 ad=0.20458 pd=1.635 as=0.45325 ps=1.995 w=1.295 l=0.15
X106 a_6957_n67# a_6564_n720# VDD VDD sky130_fd_pr__pfet_01v8 ad=0.62825 pd=2.495 as=0.27082 ps=2.135 w=1.795 l=0.15
X107 a_8616_n67# a_5936_n774# VDD VDD sky130_fd_pr__pfet_01v8 ad=0.30503 pd=1.735 as=0.32993 ps=3.02 w=1.245 l=0.15
X108 a_6019_n774# A2 a_5936_n774# GND sky130_fd_pr__nfet_01v8 ad=0.294 pd=1.54 as=0.2226 ps=2.21 w=0.84 l=0.15
X109 GND a_2786_n67# a_5114_n768# GND sky130_fd_pr__nfet_01v8 ad=0.24833 pd=1.985 as=0.20048 ps=1.305 w=0.81 l=0.15
X110 VDD a_10149_n844# Cout VDD sky130_fd_pr__pfet_01v8 ad=0.32993 pd=3.02 as=0.30503 ps=1.735 w=1.245 l=0.15
X111 a_3774_n720# a_3021_n774# a_3649_n720# GND sky130_fd_pr__nfet_01v8 ad=0.1995 pd=1.27 as=0.27075 ps=2.09 w=0.57 l=0.15
X112 a_10544_n67# a_9872_n67# a_10544_n768# GND sky130_fd_pr__nfet_01v8 ad=0.37665 pd=2.55 as=0.2835 ps=1.51 w=0.81 l=0.15
X113 GND a_8616_n67# a_10276_n844# GND sky130_fd_pr__nfet_01v8 ad=0.18805 pd=1.53 as=0.4165 ps=1.89 w=1.19 l=0.15
X114 a_9872_n67# a_9202_n67# a_9872_n839# GND sky130_fd_pr__nfet_01v8 ad=0.30872 pd=2.86 as=0.40775 ps=1.865 w=1.165 l=0.15
X115 a_4319_n844# a_4042_n67# VDD VDD sky130_fd_pr__pfet_01v8 ad=0.6405 pd=2.53 as=0.86925 ps=4.61 w=1.83 l=0.15
X116 GND Cin a_1531_n844# GND sky130_fd_pr__nfet_01v8 ad=0.18805 pd=1.53 as=0.4165 ps=1.89 w=1.19 l=0.15
X117 VDD a_9202_n67# a_9872_n67# VDD sky130_fd_pr__pfet_01v8 ad=0.47567 pd=4.12 as=0.62825 ps=2.495 w=1.795 l=0.15
X118 a_5936_n774# A2 VDD VDD sky130_fd_pr__pfet_01v8 ad=0.45325 pd=1.995 as=0.34317 ps=3.12 w=1.295 l=0.15
X119 a_9604_n720# a_8851_n774# a_9479_n720# GND sky130_fd_pr__nfet_01v8 ad=0.1995 pd=1.27 as=0.27075 ps=2.09 w=0.57 l=0.15
X120 GND B0 a_189_n774# GND sky130_fd_pr__nfet_01v8 ad=0.13268 pd=1.18 as=0.294 ps=1.54 w=0.84 l=0.15
X121 VDD a_5701_n67# a_7946_n768# VDD sky130_fd_pr__pfet_01v8 ad=0.38322 pd=2.88 as=0.30812 ps=1.74 w=1.245 l=0.15
X122 a_2786_n768# a_106_n774# GND GND sky130_fd_pr__nfet_01v8 ad=0.19845 pd=1.3 as=0.21465 ps=2.15 w=0.81 l=0.15
X123 a_106_n774# A0 VDD VDD sky130_fd_pr__pfet_01v8 ad=0.45325 pd=1.995 as=0.34317 ps=3.12 w=1.295 l=0.15
X124 a_1127_n67# a_734_n720# VDD VDD sky130_fd_pr__pfet_01v8 ad=0.62825 pd=2.495 as=0.27082 ps=2.135 w=1.795 l=0.15
X125 a_3372_n67# a_3021_n774# VDD VDD sky130_fd_pr__pfet_01v8 ad=0.2156 pd=1.37 as=0.20458 ps=1.635 w=0.88 l=0.15
X126 a_1799_n768# a_1404_n844# GND GND sky130_fd_pr__nfet_01v8 ad=0.2835 pd=1.51 as=0.18805 ps=1.53 w=0.81 l=0.15
X127 VDD a_4714_n67# Sum1 VDD sky130_fd_pr__pfet_01v8 ad=0.6731 pd=5.61 as=0.889 ps=3.24 w=2.54 l=0.15
X128 a_8616_n768# a_5936_n774# GND GND sky130_fd_pr__nfet_01v8 ad=0.19845 pd=1.3 as=0.21465 ps=2.15 w=0.81 l=0.15
X129 a_5114_n768# a_4319_n844# a_5031_n768# GND sky130_fd_pr__nfet_01v8 ad=0.20048 pd=1.305 as=0.21465 ps=2.15 w=0.81 l=0.15
X130 a_1799_n67# a_1404_n844# VDD VDD sky130_fd_pr__pfet_01v8 ad=0.43575 pd=1.945 as=0.28915 ps=2.17 w=1.245 l=0.15
X131 VDD B3 a_8851_n774# VDD sky130_fd_pr__pfet_01v8 ad=0.20458 pd=1.635 as=0.45325 ps=1.995 w=1.295 l=0.15
X132 a_2426_n935# a_2116_n768# GND GND sky130_fd_pr__nfet_01v8 ad=0.57575 pd=2.345 as=0.24833 ps=1.985 w=1.645 l=0.15
X133 a_7629_n768# a_7234_n844# GND GND sky130_fd_pr__nfet_01v8 ad=0.2835 pd=1.51 as=0.18805 ps=1.53 w=0.81 l=0.15
X134 a_9872_n67# a_9479_n720# VDD VDD sky130_fd_pr__pfet_01v8 ad=0.62825 pd=2.495 as=0.27082 ps=2.135 w=1.795 l=0.15
X135 a_4714_n67# a_4042_n67# a_4714_n768# GND sky130_fd_pr__nfet_01v8 ad=0.37665 pd=2.55 as=0.2835 ps=1.51 w=0.81 l=0.15
X136 VDD A0 a_457_n67# VDD sky130_fd_pr__pfet_01v8 ad=0.2332 pd=2.29 as=0.2156 ps=1.37 w=0.88 l=0.15
X137 a_8029_n768# a_7234_n844# a_7946_n768# GND sky130_fd_pr__nfet_01v8 ad=0.20048 pd=1.305 as=0.21465 ps=2.15 w=0.81 l=0.15
X138 VDD a_1404_n844# a_2786_n67# VDD sky130_fd_pr__pfet_01v8 ad=0.32993 pd=3.02 as=0.30503 ps=1.735 w=1.245 l=0.15
X139 Sum1 a_4714_n67# a_5341_n935# GND sky130_fd_pr__nfet_01v8 ad=0.43593 pd=3.82 as=0.57575 ps=2.345 w=1.645 l=0.15
X140 Sum1 a_5031_n768# VDD VDD sky130_fd_pr__pfet_01v8 ad=0.889 pd=3.24 as=0.38322 ps=2.88 w=2.54 l=0.15
X141 a_7234_n844# a_6957_n67# VDD VDD sky130_fd_pr__pfet_01v8 ad=0.6405 pd=2.53 as=0.86925 ps=4.61 w=1.83 l=0.15
X142 VDD a_8616_n67# a_10861_n768# VDD sky130_fd_pr__pfet_01v8 ad=0.38322 pd=2.88 as=0.30812 ps=1.74 w=1.245 l=0.15
X143 a_457_n720# a_106_n774# GND GND sky130_fd_pr__nfet_01v8 ad=0.13965 pd=1.06 as=0.13268 ps=1.18 w=0.57 l=0.15
.ends
