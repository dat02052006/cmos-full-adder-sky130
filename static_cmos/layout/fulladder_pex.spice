* NGSPICE file created from TOP_FLAT.ext - technology: sky130A

.subckt fulladder VDD GND Sum A B Cin Cout
X0 VDD B a_106_n774# VDD sky130_fd_pr__pfet_01v8 ad=0.20458 pd=1.635 as=0.45325 ps=1.995 w=1.295 l=0.15
X1 VDD a_457_n67# a_1127_n67# VDD sky130_fd_pr__pfet_01v8 ad=0.47567 pd=4.12 as=0.62825 ps=2.495 w=1.795 l=0.15
X2 VDD a_1127_n67# a_1799_n67# VDD sky130_fd_pr__pfet_01v8 ad=0.32993 pd=3.02 as=0.43575 ps=1.945 w=1.245 l=0.15
X3 a_1127_n839# a_734_n720# GND GND sky130_fd_pr__nfet_01v8 ad=0.40775 pd=1.865 as=0.17572 ps=1.505 w=1.165 l=0.15
X4 a_1531_n844# a_1127_n67# a_1404_n844# GND sky130_fd_pr__nfet_01v8 ad=0.4165 pd=1.89 as=0.57715 ps=3.35 w=1.19 l=0.15
X5 GND B a_859_n720# GND sky130_fd_pr__nfet_01v8 ad=0.17572 pd=1.505 as=0.1995 ps=1.27 w=0.57 l=0.15
X6 VDD Cin a_2116_n768# VDD sky130_fd_pr__pfet_01v8 ad=0.38322 pd=2.88 as=0.30812 ps=1.74 w=1.245 l=0.15
X7 a_2199_n768# a_1404_n844# a_2116_n768# GND sky130_fd_pr__nfet_01v8 ad=0.20048 pd=1.305 as=0.21465 ps=2.15 w=0.81 l=0.15
X8 Cout a_1404_n844# a_2786_n768# GND sky130_fd_pr__nfet_01v8 ad=0.21465 pd=2.15 as=0.19845 ps=1.3 w=0.81 l=0.15
X9 a_1799_n67# a_1127_n67# a_1799_n768# GND sky130_fd_pr__nfet_01v8 ad=0.37665 pd=2.55 as=0.2835 ps=1.51 w=0.81 l=0.15
X10 Sum a_1799_n67# a_2426_n935# GND sky130_fd_pr__nfet_01v8 ad=0.43593 pd=3.82 as=0.57575 ps=2.345 w=1.645 l=0.15
X11 a_457_n67# a_106_n774# VDD VDD sky130_fd_pr__pfet_01v8 ad=0.2156 pd=1.37 as=0.20458 ps=1.635 w=0.88 l=0.15
X12 a_457_n67# A a_457_n720# GND sky130_fd_pr__nfet_01v8 ad=0.27075 pd=2.09 as=0.13965 ps=1.06 w=0.57 l=0.15
X13 GND Cin a_2199_n768# GND sky130_fd_pr__nfet_01v8 ad=0.24833 pd=1.985 as=0.20048 ps=1.305 w=0.81 l=0.15
X14 Cout a_106_n774# VDD VDD sky130_fd_pr__pfet_01v8 ad=0.30503 pd=1.735 as=0.32993 ps=3.02 w=1.245 l=0.15
X15 a_189_n774# A a_106_n774# GND sky130_fd_pr__nfet_01v8 ad=0.294 pd=1.54 as=0.2226 ps=2.21 w=0.84 l=0.15
X16 VDD B a_734_n720# VDD sky130_fd_pr__pfet_01v8 ad=0.27082 pd=2.135 as=0.308 ps=1.58 w=0.88 l=0.15
X17 a_2116_n768# a_1404_n844# VDD VDD sky130_fd_pr__pfet_01v8 ad=0.30812 pd=1.74 as=0.32993 ps=3.02 w=1.245 l=0.15
X18 VDD Cin a_1404_n844# VDD sky130_fd_pr__pfet_01v8 ad=0.28915 pd=2.17 as=0.6405 ps=2.53 w=1.83 l=0.15
X19 a_859_n720# a_106_n774# a_734_n720# GND sky130_fd_pr__nfet_01v8 ad=0.1995 pd=1.27 as=0.27075 ps=2.09 w=0.57 l=0.15
X20 a_734_n720# a_106_n774# VDD VDD sky130_fd_pr__pfet_01v8 ad=0.308 pd=1.58 as=0.2332 ps=2.29 w=0.88 l=0.15
X21 Sum a_2116_n768# VDD VDD sky130_fd_pr__pfet_01v8 ad=0.889 pd=3.24 as=0.38322 ps=2.88 w=2.54 l=0.15
X22 a_1127_n67# a_457_n67# a_1127_n839# GND sky130_fd_pr__nfet_01v8 ad=0.30872 pd=2.86 as=0.40775 ps=1.865 w=1.165 l=0.15
X23 a_1404_n844# a_1127_n67# VDD VDD sky130_fd_pr__pfet_01v8 ad=0.6405 pd=2.53 as=0.86925 ps=4.61 w=1.83 l=0.15
X24 VDD a_1799_n67# Sum VDD sky130_fd_pr__pfet_01v8 ad=0.6731 pd=5.61 as=0.889 ps=3.24 w=2.54 l=0.15
X25 GND B a_189_n774# GND sky130_fd_pr__nfet_01v8 ad=0.13268 pd=1.18 as=0.294 ps=1.54 w=0.84 l=0.15
X26 GND Cin a_1531_n844# GND sky130_fd_pr__nfet_01v8 ad=0.18805 pd=1.53 as=0.4165 ps=1.89 w=1.19 l=0.15
X27 a_106_n774# A VDD VDD sky130_fd_pr__pfet_01v8 ad=0.45325 pd=1.995 as=0.34317 ps=3.12 w=1.295 l=0.15
X28 a_1127_n67# a_734_n720# VDD VDD sky130_fd_pr__pfet_01v8 ad=0.62825 pd=2.495 as=0.27082 ps=2.135 w=1.795 l=0.15
X29 a_2786_n768# a_106_n774# GND GND sky130_fd_pr__nfet_01v8 ad=0.19845 pd=1.3 as=0.21465 ps=2.15 w=0.81 l=0.15
X30 a_1799_n67# a_1404_n844# VDD VDD sky130_fd_pr__pfet_01v8 ad=0.43575 pd=1.945 as=0.28915 ps=2.17 w=1.245 l=0.15
X31 a_1799_n768# a_1404_n844# GND GND sky130_fd_pr__nfet_01v8 ad=0.2835 pd=1.51 as=0.18805 ps=1.53 w=0.81 l=0.15
X32 a_2426_n935# a_2116_n768# GND GND sky130_fd_pr__nfet_01v8 ad=0.57575 pd=2.345 as=0.24833 ps=1.985 w=1.645 l=0.15
X33 VDD A a_457_n67# VDD sky130_fd_pr__pfet_01v8 ad=0.2332 pd=2.29 as=0.2156 ps=1.37 w=0.88 l=0.15
X34 VDD a_1404_n844# Cout VDD sky130_fd_pr__pfet_01v8 ad=0.32993 pd=3.02 as=0.30503 ps=1.735 w=1.245 l=0.15
X35 a_457_n720# a_106_n774# GND GND sky130_fd_pr__nfet_01v8 ad=0.13965 pd=1.06 as=0.13268 ps=1.18 w=0.57 l=0.15
C0 VDD a_457_n67# 0.33103f
C1 a_1404_n844# a_106_n774# 0.11776f
C2 VDD Cin 0.12058f
C3 Cout VDD 0.20465f
C4 a_1404_n844# VDD 0.67922f
C5 a_457_n67# a_1799_n67# 0
C6 a_1799_n67# Cin 0.05573f
C7 Cout a_1799_n67# 0.01134f
C8 a_1404_n844# a_1799_n67# 0.30759f
C9 a_1127_n67# a_1531_n844# 0.00102f
C10 a_734_n720# a_2116_n768# 0
C11 a_189_n774# A 0
C12 B a_2116_n768# 0
C13 a_189_n774# B 0
C14 Cin a_1531_n844# 0.00138f
C15 Sum a_2116_n768# 0.10816f
C16 a_2199_n768# a_2116_n768# 0.01666f
C17 a_1404_n844# a_1531_n844# 0.02689f
C18 VDD a_106_n774# 0.34652f
C19 a_106_n774# a_2426_n935# 0.01f
C20 a_1127_n67# a_1127_n839# 0.0325f
C21 a_106_n774# a_1799_n67# 0.0701f
C22 A a_734_n720# 0.01667f
C23 VDD a_1799_n67# 0.2757f
C24 B a_734_n720# 0.19416f
C25 a_457_n67# a_1127_n839# 0
C26 B A 0.10289f
C27 a_1799_n67# a_2426_n935# 0
C28 Sum a_734_n720# 0
C29 Sum B 0
C30 a_1404_n844# a_1127_n839# 0
C31 a_457_n720# A 0
C32 Sum a_2199_n768# 0
C33 a_106_n774# a_1531_n844# 0.00773f
C34 a_734_n720# a_859_n720# 0.01015f
C35 a_1127_n67# a_2116_n768# 0.01648f
C36 B a_859_n720# 0
C37 a_1799_n67# a_1531_n844# 0
C38 a_457_n67# a_2116_n768# 0
C39 a_189_n774# a_457_n67# 0
C40 Cin a_2116_n768# 0.19341f
C41 Cout a_2116_n768# 0.00293f
C42 a_106_n774# a_1127_n839# 0.00759f
C43 a_1404_n844# a_2116_n768# 0.11187f
C44 a_1127_n67# a_734_n720# 0.08357f
C45 a_1127_n67# A 0
C46 Sum a_2786_n768# 0
C47 a_1127_n67# B 0.02726f
C48 Sum a_1127_n67# 0
C49 a_1127_n67# a_2199_n768# 0
C50 a_734_n720# a_457_n67# 0.31033f
C51 a_734_n720# Cin 0
C52 A a_457_n67# 0.10657f
C53 a_1127_n67# a_1799_n768# 0
C54 A Cin 0
C55 B a_457_n67# 0.06626f
C56 a_1404_n844# a_734_n720# 0.0012f
C57 B Cin 0
C58 Sum a_457_n67# 0
C59 a_1404_n844# A 0
C60 Sum Cin 0.02541f
C61 a_457_n720# a_457_n67# 0.00732f
C62 Cin a_2199_n768# 0.00105f
C63 a_1404_n844# B 0
C64 Sum Cout 0.02966f
C65 a_1127_n67# a_859_n720# 0
C66 a_106_n774# a_2116_n768# 0.05056f
C67 Sum a_1404_n844# 0.05185f
C68 a_189_n774# a_106_n774# 0.02979f
C69 a_1404_n844# a_2199_n768# 0
C70 VDD a_2116_n768# 0.27275f
C71 a_189_n774# VDD 0
C72 a_1404_n844# a_1799_n768# 0
C73 a_2426_n935# a_2116_n768# 0.00239f
C74 a_1799_n67# a_2116_n768# 0.26513f
C75 a_2786_n768# a_1127_n67# 0
C76 a_734_n720# a_106_n774# 0.10402f
C77 A a_106_n774# 0.2192f
C78 B a_106_n774# 0.27199f
C79 VDD a_734_n720# 0.21215f
C80 Sum a_106_n774# 0.10697f
C81 VDD A 0.14769f
C82 a_106_n774# a_2199_n768# 0.0039f
C83 a_2786_n768# Cout 0.01858f
C84 B VDD 0.11655f
C85 a_457_n720# a_106_n774# 0.00509f
C86 a_1127_n67# a_457_n67# 0.17033f
C87 a_734_n720# a_1799_n67# 0.00318f
C88 a_2786_n768# a_1404_n844# 0
C89 Sum VDD 0.39367f
C90 a_1127_n67# Cin 0.10922f
C91 A a_1799_n67# 0
C92 a_1799_n768# a_106_n774# 0.00552f
C93 Cout a_1127_n67# 0
C94 Sum a_2426_n935# 0.04565f
C95 B a_1799_n67# 0
C96 a_1404_n844# a_1127_n67# 0.39034f
C97 Sum a_1799_n67# 0.13741f
C98 a_106_n774# a_859_n720# 0.00496f
C99 a_457_n67# Cin 0
C100 Cout a_457_n67# 0
C101 a_1799_n768# a_1799_n67# 0.01851f
C102 Cout Cin 0
C103 a_1404_n844# a_457_n67# 0.0317f
C104 a_1404_n844# Cin 0.18314f
C105 Cout a_1404_n844# 0.13192f
C106 a_2786_n768# a_106_n774# 0.00297f
C107 a_1127_n67# a_106_n774# 0.10876f
C108 a_1127_n67# VDD 0.41967f
C109 a_734_n720# a_1127_n839# 0
C110 a_1127_n67# a_2426_n935# 0
C111 a_457_n67# a_106_n774# 0.11724f
C112 a_1127_n67# a_1799_n67# 0.09702f
C113 a_106_n774# Cin 0.18446f
C114 Cout a_106_n774# 0.04775f
C115 Cout GND 0.30782f
C116 Sum GND 1.43715f
C117 VDD GND 13.04201f
C118 a_2786_n768# GND 0.0169f
C119 a_2426_n935# GND 0.55911f
C120 a_2199_n768# GND 0.56941f
C121 a_1799_n768# GND 0.02301f
C122 a_1531_n844# GND 0.03505f
C123 a_1127_n839# GND 0.88435f
C124 a_859_n720# GND 0.01638f
C125 a_457_n720# GND 0.35866f
C126 a_189_n774# GND 0.02652f
C127 a_1799_n67# GND 0.15973f
.ends
