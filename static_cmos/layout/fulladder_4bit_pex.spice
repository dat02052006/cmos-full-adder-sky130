* SPICE3 file created from fulladder_4bit.ext - technology: sky130A

X0 a_8616_n67# a_7234_n844# a_8616_n768# GND sky130_fd_pr__nfet_01v8 ad=0.21465 pd=2.15 as=0.19845 ps=1.3 w=0.81 l=0.15
X1 VDD B0 a_106_n774# VDD sky130_fd_pr__pfet_01v8 ad=0.20458 pd=1.635 as=0.45325 ps=1.995 w=1.295 l=0.15
X2 a_3649_n720# a_3021_n774# VDD VDD sky130_fd_pr__pfet_01v8 ad=0.308 pd=1.58 as=0.2332 ps=2.29 w=0.88 l=0.15
X3 a_6287_n67# A2 a_6287_n720# GND sky130_fd_pr__nfet_01v8 ad=0.27075 pd=2.09 as=0.13965 ps=1.06 w=0.57 l=0.15
X4 VDD a_457_n67# a_1127_n67# VDD sky130_fd_pr__pfet_01v8 ad=0.47567 pd=4.12 as=0.62825 ps=2.495 w=1.795 l=0.15
X5 a_4714_n67# a_4319_n844# VDD VDD sky130_fd_pr__pfet_01v8 ad=0.43575 pd=1.945 as=0.28915 ps=2.17 w=1.245 l=0.15
X6 VDD a_1127_n67# a_1799_n67# VDD sky130_fd_pr__pfet_01v8 ad=0.32993 pd=3.02 as=0.43575 ps=1.945 w=1.245 l=0.15
X7 a_6287_n67# a_5936_n774# VDD VDD sky130_fd_pr__pfet_01v8 ad=0.2156 pd=1.37 as=0.20458 ps=1.635 w=0.88 l=0.15
X8 VDD A3 a_9202_n67# VDD sky130_fd_pr__pfet_01v8 ad=0.2332 pd=2.29 as=0.2156 ps=1.37 w=0.88 l=0.15
X9 a_7946_n768# a_7234_n844# VDD VDD sky130_fd_pr__pfet_01v8 ad=0.30812 pd=1.74 as=0.32993 ps=3.02 w=1.245 l=0.15
X10 VDD a_7629_n67# Sum2 VDD sky130_fd_pr__pfet_01v8 ad=0.6731 pd=5.61 as=0.889 ps=3.24 w=2.54 l=0.15
X11 a_11531_n768# a_8851_n774# GND GND sky130_fd_pr__nfet_01v8 ad=0.19845 pd=1.3 as=0.21465 ps=2.15 w=0.81 l=0.15
X12 GND B1 a_3104_n774# GND sky130_fd_pr__nfet_01v8 ad=0.13268 pd=1.18 as=0.294 ps=1.54 w=0.84 l=0.15
X13 a_10544_n768# a_10149_n844# GND GND sky130_fd_pr__nfet_01v8 ad=0.2835 pd=1.51 as=0.18805 ps=1.53 w=0.81 l=0.15
X14 a_1127_n839# a_734_n720# GND GND sky130_fd_pr__nfet_01v8 ad=0.40775 pd=1.865 as=0.17572 ps=1.505 w=1.165 l=0.15
X15 VDD a_5701_n67# a_7234_n844# VDD sky130_fd_pr__pfet_01v8 ad=0.28915 pd=2.17 as=0.6405 ps=2.53 w=1.83 l=0.15
X16 GND a_5701_n67# a_8029_n768# GND sky130_fd_pr__nfet_01v8 ad=0.24833 pd=1.985 as=0.20048 ps=1.305 w=0.81 l=0.15
X17 a_1531_n844# a_1127_n67# a_1404_n844# GND sky130_fd_pr__nfet_01v8 ad=0.4165 pd=1.89 as=0.57715 ps=3.35 w=1.19 l=0.15
X18 Cout a_8851_n774# VDD VDD sky130_fd_pr__pfet_01v8 ad=0.30503 pd=1.735 as=0.32993 ps=3.02 w=1.245 l=0.15
X19 VDD a_4319_n844# a_5701_n67# VDD sky130_fd_pr__pfet_01v8 ad=0.32993 pd=3.02 as=0.30503 ps=1.735 w=1.245 l=0.15
X20 a_10944_n768# a_10149_n844# a_10861_n768# GND sky130_fd_pr__nfet_01v8 ad=0.20048 pd=1.305 as=0.21465 ps=2.15 w=0.81 l=0.15
X21 a_8934_n774# A3 a_8851_n774# GND sky130_fd_pr__nfet_01v8 ad=0.294 pd=1.54 as=0.2226 ps=2.21 w=0.84 l=0.15
X22 GND B0 a_859_n720# GND sky130_fd_pr__nfet_01v8 ad=0.17572 pd=1.505 as=0.1995 ps=1.27 w=0.57 l=0.15
X23 a_10149_n844# a_9872_n67# VDD VDD sky130_fd_pr__pfet_01v8 ad=0.6405 pd=2.53 as=0.86925 ps=4.61 w=1.83 l=0.15
X24 a_11171_n935# a_10861_n768# GND GND sky130_fd_pr__nfet_01v8 ad=0.57575 pd=2.345 as=0.24833 ps=1.985 w=1.645 l=0.15
X25 GND B3 a_8934_n774# GND sky130_fd_pr__nfet_01v8 ad=0.13268 pd=1.18 as=0.294 ps=1.54 w=0.84 l=0.15
X26 a_6689_n720# a_5936_n774# a_6564_n720# GND sky130_fd_pr__nfet_01v8 ad=0.1995 pd=1.27 as=0.27075 ps=2.09 w=0.57 l=0.15
X27 Sum2 a_7946_n768# VDD VDD sky130_fd_pr__pfet_01v8 ad=0.889 pd=3.24 as=0.38322 ps=2.88 w=2.54 l=0.15
X28 a_7361_n844# a_6957_n67# a_7234_n844# GND sky130_fd_pr__nfet_01v8 ad=0.4165 pd=1.89 as=0.57715 ps=3.35 w=1.19 l=0.15
X29 GND B1 a_3774_n720# GND sky130_fd_pr__nfet_01v8 ad=0.17572 pd=1.505 as=0.1995 ps=1.27 w=0.57 l=0.15
X30 VDD Cin a_2116_n768# VDD sky130_fd_pr__pfet_01v8 ad=0.38322 pd=2.88 as=0.30812 ps=1.74 w=1.245 l=0.15
X31 VDD B1 a_3649_n720# VDD sky130_fd_pr__pfet_01v8 ad=0.27082 pd=2.135 as=0.308 ps=1.58 w=0.88 l=0.15
X32 VDD a_3372_n67# a_4042_n67# VDD sky130_fd_pr__pfet_01v8 ad=0.47567 pd=4.12 as=0.62825 ps=2.495 w=1.795 l=0.15
X33 GND a_2786_n67# a_4446_n844# GND sky130_fd_pr__nfet_01v8 ad=0.18805 pd=1.53 as=0.4165 ps=1.89 w=1.19 l=0.15
X34 a_4042_n67# a_3372_n67# a_4042_n839# GND sky130_fd_pr__nfet_01v8 ad=0.30872 pd=2.86 as=0.40775 ps=1.865 w=1.165 l=0.15
X35 Cout a_10149_n844# a_11531_n768# GND sky130_fd_pr__nfet_01v8 ad=0.21465 pd=2.15 as=0.19845 ps=1.3 w=0.81 l=0.15
X36 a_2786_n67# a_1404_n844# a_2786_n768# GND sky130_fd_pr__nfet_01v8 ad=0.21465 pd=2.15 as=0.19845 ps=1.3 w=0.81 l=0.15
X37 VDD a_4042_n67# a_4714_n67# VDD sky130_fd_pr__pfet_01v8 ad=0.32993 pd=3.02 as=0.43575 ps=1.945 w=1.245 l=0.15
X38 GND B3 a_9604_n720# GND sky130_fd_pr__nfet_01v8 ad=0.17572 pd=1.505 as=0.1995 ps=1.27 w=0.57 l=0.15
X39 a_6564_n720# a_5936_n774# VDD VDD sky130_fd_pr__pfet_01v8 ad=0.308 pd=1.58 as=0.2332 ps=2.29 w=0.88 l=0.15
X40 a_9872_n839# a_9479_n720# GND GND sky130_fd_pr__nfet_01v8 ad=0.40775 pd=1.865 as=0.17572 ps=1.505 w=1.165 l=0.15
X41 a_2199_n768# a_1404_n844# a_2116_n768# GND sky130_fd_pr__nfet_01v8 ad=0.20048 pd=1.305 as=0.21465 ps=2.15 w=0.81 l=0.15
X42 a_8851_n774# A3 VDD VDD sky130_fd_pr__pfet_01v8 ad=0.45325 pd=1.995 as=0.34317 ps=3.12 w=1.295 l=0.15
X43 a_9202_n67# a_8851_n774# VDD VDD sky130_fd_pr__pfet_01v8 ad=0.2156 pd=1.37 as=0.20458 ps=1.635 w=0.88 l=0.15
X44 a_3372_n720# a_3021_n774# GND GND sky130_fd_pr__nfet_01v8 ad=0.13965 pd=1.06 as=0.13268 ps=1.18 w=0.57 l=0.15
X45 a_7629_n67# a_7234_n844# VDD VDD sky130_fd_pr__pfet_01v8 ad=0.43575 pd=1.945 as=0.28915 ps=2.17 w=1.245 l=0.15
X46 a_1799_n67# a_1127_n67# a_1799_n768# GND sky130_fd_pr__nfet_01v8 ad=0.37665 pd=2.55 as=0.2835 ps=1.51 w=0.81 l=0.15
X47 a_4042_n67# a_3649_n720# VDD VDD sky130_fd_pr__pfet_01v8 ad=0.62825 pd=2.495 as=0.27082 ps=2.135 w=1.795 l=0.15
X48 a_9202_n720# a_8851_n774# GND GND sky130_fd_pr__nfet_01v8 ad=0.13965 pd=1.06 as=0.13268 ps=1.18 w=0.57 l=0.15
X49 a_5341_n935# a_5031_n768# GND GND sky130_fd_pr__nfet_01v8 ad=0.57575 pd=2.345 as=0.24833 ps=1.985 w=1.645 l=0.15
X50 Sum0 a_1799_n67# a_2426_n935# GND sky130_fd_pr__nfet_01v8 ad=0.43593 pd=3.82 as=0.57575 ps=2.345 w=1.645 l=0.15
X51 Sum3 a_10861_n768# VDD VDD sky130_fd_pr__pfet_01v8 ad=0.889 pd=3.24 as=0.38322 ps=2.88 w=2.54 l=0.15
X52 a_7629_n67# a_6957_n67# a_7629_n768# GND sky130_fd_pr__nfet_01v8 ad=0.37665 pd=2.55 as=0.2835 ps=1.51 w=0.81 l=0.15
X53 VDD a_8616_n67# a_10149_n844# VDD sky130_fd_pr__pfet_01v8 ad=0.28915 pd=2.17 as=0.6405 ps=2.53 w=1.83 l=0.15
X54 GND Cin a_2199_n768# GND sky130_fd_pr__nfet_01v8 ad=0.24833 pd=1.985 as=0.20048 ps=1.305 w=0.81 l=0.15
X55 a_457_n67# A0 a_457_n720# GND sky130_fd_pr__nfet_01v8 ad=0.27075 pd=2.09 as=0.13965 ps=1.06 w=0.57 l=0.15
X56 a_3021_n774# A1 VDD VDD sky130_fd_pr__pfet_01v8 ad=0.45325 pd=1.995 as=0.34317 ps=3.12 w=1.295 l=0.15
X57 Sum2 a_7629_n67# a_8256_n935# GND sky130_fd_pr__nfet_01v8 ad=0.43593 pd=3.82 as=0.57575 ps=2.345 w=1.645 l=0.15
X58 a_457_n67# a_106_n774# VDD VDD sky130_fd_pr__pfet_01v8 ad=0.2156 pd=1.37 as=0.20458 ps=1.635 w=0.88 l=0.15
X59 a_2786_n67# a_106_n774# VDD VDD sky130_fd_pr__pfet_01v8 ad=0.30503 pd=1.735 as=0.32993 ps=3.02 w=1.245 l=0.15
X60 a_10276_n844# a_9872_n67# a_10149_n844# GND sky130_fd_pr__nfet_01v8 ad=0.4165 pd=1.89 as=0.57715 ps=3.35 w=1.19 l=0.15
X61 VDD B2 a_6564_n720# VDD sky130_fd_pr__pfet_01v8 ad=0.27082 pd=2.135 as=0.308 ps=1.58 w=0.88 l=0.15
X62 a_9479_n720# a_8851_n774# VDD VDD sky130_fd_pr__pfet_01v8 ad=0.308 pd=1.58 as=0.2332 ps=2.29 w=0.88 l=0.15
X63 VDD a_6287_n67# a_6957_n67# VDD sky130_fd_pr__pfet_01v8 ad=0.47567 pd=4.12 as=0.62825 ps=2.495 w=1.795 l=0.15
X64 a_189_n774# A0 a_106_n774# GND sky130_fd_pr__nfet_01v8 ad=0.294 pd=1.54 as=0.2226 ps=2.21 w=0.84 l=0.15
X65 a_9202_n67# A3 a_9202_n720# GND sky130_fd_pr__nfet_01v8 ad=0.27075 pd=2.09 as=0.13965 ps=1.06 w=0.57 l=0.15
X66 VDD B0 a_734_n720# VDD sky130_fd_pr__pfet_01v8 ad=0.27082 pd=2.135 as=0.308 ps=1.58 w=0.88 l=0.15
X67 VDD a_6957_n67# a_7629_n67# VDD sky130_fd_pr__pfet_01v8 ad=0.32993 pd=3.02 as=0.43575 ps=1.945 w=1.245 l=0.15
X68 a_2116_n768# a_1404_n844# VDD VDD sky130_fd_pr__pfet_01v8 ad=0.30812 pd=1.74 as=0.32993 ps=3.02 w=1.245 l=0.15
X69 VDD A1 a_3372_n67# VDD sky130_fd_pr__pfet_01v8 ad=0.2332 pd=2.29 as=0.2156 ps=1.37 w=0.88 l=0.15
X70 a_10861_n768# a_10149_n844# VDD VDD sky130_fd_pr__pfet_01v8 ad=0.30812 pd=1.74 as=0.32993 ps=3.02 w=1.245 l=0.15
X71 VDD a_10544_n67# Sum3 VDD sky130_fd_pr__pfet_01v8 ad=0.6731 pd=5.61 as=0.889 ps=3.24 w=2.54 l=0.15
X72 a_5701_n768# a_3021_n774# GND GND sky130_fd_pr__nfet_01v8 ad=0.19845 pd=1.3 as=0.21465 ps=2.15 w=0.81 l=0.15
X73 a_859_n720# a_106_n774# a_734_n720# GND sky130_fd_pr__nfet_01v8 ad=0.1995 pd=1.27 as=0.27075 ps=2.09 w=0.57 l=0.15
X74 GND B2 a_6019_n774# GND sky130_fd_pr__nfet_01v8 ad=0.13268 pd=1.18 as=0.294 ps=1.54 w=0.84 l=0.15
X75 VDD Cin a_1404_n844# VDD sky130_fd_pr__pfet_01v8 ad=0.28915 pd=2.17 as=0.6405 ps=2.53 w=1.83 l=0.15
X76 a_4714_n768# a_4319_n844# GND GND sky130_fd_pr__nfet_01v8 ad=0.2835 pd=1.51 as=0.18805 ps=1.53 w=0.81 l=0.15
X77 a_734_n720# a_106_n774# VDD VDD sky130_fd_pr__pfet_01v8 ad=0.308 pd=1.58 as=0.2332 ps=2.29 w=0.88 l=0.15
X78 VDD B1 a_3021_n774# VDD sky130_fd_pr__pfet_01v8 ad=0.20458 pd=1.635 as=0.45325 ps=1.995 w=1.295 l=0.15
X79 a_4446_n844# a_4042_n67# a_4319_n844# GND sky130_fd_pr__nfet_01v8 ad=0.4165 pd=1.89 as=0.57715 ps=3.35 w=1.19 l=0.15
X80 a_4042_n839# a_3649_n720# GND GND sky130_fd_pr__nfet_01v8 ad=0.40775 pd=1.865 as=0.17572 ps=1.505 w=1.165 l=0.15
X81 Sum0 a_2116_n768# VDD VDD sky130_fd_pr__pfet_01v8 ad=0.889 pd=3.24 as=0.38322 ps=2.88 w=2.54 l=0.15
X82 a_5701_n67# a_3021_n774# VDD VDD sky130_fd_pr__pfet_01v8 ad=0.30503 pd=1.735 as=0.32993 ps=3.02 w=1.245 l=0.15
X83 a_1127_n67# a_457_n67# a_1127_n839# GND sky130_fd_pr__nfet_01v8 ad=0.30872 pd=2.86 as=0.40775 ps=1.865 w=1.165 l=0.15
X84 Sum3 a_10544_n67# a_11171_n935# GND sky130_fd_pr__nfet_01v8 ad=0.43593 pd=3.82 as=0.57575 ps=2.345 w=1.645 l=0.15
X85 VDD a_9872_n67# a_10544_n67# VDD sky130_fd_pr__pfet_01v8 ad=0.32993 pd=3.02 as=0.43575 ps=1.945 w=1.245 l=0.15
X86 VDD B3 a_9479_n720# VDD sky130_fd_pr__pfet_01v8 ad=0.27082 pd=2.135 as=0.308 ps=1.58 w=0.88 l=0.15
X87 GND B2 a_6689_n720# GND sky130_fd_pr__nfet_01v8 ad=0.17572 pd=1.505 as=0.1995 ps=1.27 w=0.57 l=0.15
X88 VDD a_7234_n844# a_8616_n67# VDD sky130_fd_pr__pfet_01v8 ad=0.32993 pd=3.02 as=0.30503 ps=1.735 w=1.245 l=0.15
X89 a_6957_n67# a_6287_n67# a_6957_n839# GND sky130_fd_pr__nfet_01v8 ad=0.30872 pd=2.86 as=0.40775 ps=1.865 w=1.165 l=0.15
X90 a_6957_n839# a_6564_n720# GND GND sky130_fd_pr__nfet_01v8 ad=0.40775 pd=1.865 as=0.17572 ps=1.505 w=1.165 l=0.15
X91 GND a_5701_n67# a_7361_n844# GND sky130_fd_pr__nfet_01v8 ad=0.18805 pd=1.53 as=0.4165 ps=1.89 w=1.19 l=0.15
X92 a_1404_n844# a_1127_n67# VDD VDD sky130_fd_pr__pfet_01v8 ad=0.6405 pd=2.53 as=0.86925 ps=4.61 w=1.83 l=0.15
X93 GND a_8616_n67# a_10944_n768# GND sky130_fd_pr__nfet_01v8 ad=0.24833 pd=1.985 as=0.20048 ps=1.305 w=0.81 l=0.15
X94 a_5701_n67# a_4319_n844# a_5701_n768# GND sky130_fd_pr__nfet_01v8 ad=0.21465 pd=2.15 as=0.19845 ps=1.3 w=0.81 l=0.15
X95 a_5031_n768# a_4319_n844# VDD VDD sky130_fd_pr__pfet_01v8 ad=0.30812 pd=1.74 as=0.32993 ps=3.02 w=1.245 l=0.15
X96 VDD a_2786_n67# a_5031_n768# VDD sky130_fd_pr__pfet_01v8 ad=0.38322 pd=2.88 as=0.30812 ps=1.74 w=1.245 l=0.15
X97 a_3372_n67# A1 a_3372_n720# GND sky130_fd_pr__nfet_01v8 ad=0.27075 pd=2.09 as=0.13965 ps=1.06 w=0.57 l=0.15
X98 VDD A2 a_6287_n67# VDD sky130_fd_pr__pfet_01v8 ad=0.2332 pd=2.29 as=0.2156 ps=1.37 w=0.88 l=0.15
X99 a_6287_n720# a_5936_n774# GND GND sky130_fd_pr__nfet_01v8 ad=0.13965 pd=1.06 as=0.13268 ps=1.18 w=0.57 l=0.15
X100 a_10544_n67# a_10149_n844# VDD VDD sky130_fd_pr__pfet_01v8 ad=0.43575 pd=1.945 as=0.28915 ps=2.17 w=1.245 l=0.15
X101 a_8256_n935# a_7946_n768# GND GND sky130_fd_pr__nfet_01v8 ad=0.57575 pd=2.345 as=0.24833 ps=1.985 w=1.645 l=0.15
X102 a_3104_n774# A1 a_3021_n774# GND sky130_fd_pr__nfet_01v8 ad=0.294 pd=1.54 as=0.2226 ps=2.21 w=0.84 l=0.15
X103 VDD a_1799_n67# Sum0 VDD sky130_fd_pr__pfet_01v8 ad=0.6731 pd=5.61 as=0.889 ps=3.24 w=2.54 l=0.15
X104 VDD a_2786_n67# a_4319_n844# VDD sky130_fd_pr__pfet_01v8 ad=0.28915 pd=2.17 as=0.6405 ps=2.53 w=1.83 l=0.15
X105 VDD B2 a_5936_n774# VDD sky130_fd_pr__pfet_01v8 ad=0.20458 pd=1.635 as=0.45325 ps=1.995 w=1.295 l=0.15
X106 a_6957_n67# a_6564_n720# VDD VDD sky130_fd_pr__pfet_01v8 ad=0.62825 pd=2.495 as=0.27082 ps=2.135 w=1.795 l=0.15
X107 a_8616_n67# a_5936_n774# VDD VDD sky130_fd_pr__pfet_01v8 ad=0.30503 pd=1.735 as=0.32993 ps=3.02 w=1.245 l=0.15
X108 a_6019_n774# A2 a_5936_n774# GND sky130_fd_pr__nfet_01v8 ad=0.294 pd=1.54 as=0.2226 ps=2.21 w=0.84 l=0.15
X109 GND a_2786_n67# a_5114_n768# GND sky130_fd_pr__nfet_01v8 ad=0.24833 pd=1.985 as=0.20048 ps=1.305 w=0.81 l=0.15
X110 VDD a_10149_n844# Cout VDD sky130_fd_pr__pfet_01v8 ad=0.32993 pd=3.02 as=0.30503 ps=1.735 w=1.245 l=0.15
X111 a_3774_n720# a_3021_n774# a_3649_n720# GND sky130_fd_pr__nfet_01v8 ad=0.1995 pd=1.27 as=0.27075 ps=2.09 w=0.57 l=0.15
X112 a_10544_n67# a_9872_n67# a_10544_n768# GND sky130_fd_pr__nfet_01v8 ad=0.37665 pd=2.55 as=0.2835 ps=1.51 w=0.81 l=0.15
X113 GND a_8616_n67# a_10276_n844# GND sky130_fd_pr__nfet_01v8 ad=0.18805 pd=1.53 as=0.4165 ps=1.89 w=1.19 l=0.15
X114 a_9872_n67# a_9202_n67# a_9872_n839# GND sky130_fd_pr__nfet_01v8 ad=0.30872 pd=2.86 as=0.40775 ps=1.865 w=1.165 l=0.15
X115 a_4319_n844# a_4042_n67# VDD VDD sky130_fd_pr__pfet_01v8 ad=0.6405 pd=2.53 as=0.86925 ps=4.61 w=1.83 l=0.15
X116 GND Cin a_1531_n844# GND sky130_fd_pr__nfet_01v8 ad=0.18805 pd=1.53 as=0.4165 ps=1.89 w=1.19 l=0.15
X117 VDD a_9202_n67# a_9872_n67# VDD sky130_fd_pr__pfet_01v8 ad=0.47567 pd=4.12 as=0.62825 ps=2.495 w=1.795 l=0.15
X118 a_5936_n774# A2 VDD VDD sky130_fd_pr__pfet_01v8 ad=0.45325 pd=1.995 as=0.34317 ps=3.12 w=1.295 l=0.15
X119 a_9604_n720# a_8851_n774# a_9479_n720# GND sky130_fd_pr__nfet_01v8 ad=0.1995 pd=1.27 as=0.27075 ps=2.09 w=0.57 l=0.15
X120 GND B0 a_189_n774# GND sky130_fd_pr__nfet_01v8 ad=0.13268 pd=1.18 as=0.294 ps=1.54 w=0.84 l=0.15
X121 VDD a_5701_n67# a_7946_n768# VDD sky130_fd_pr__pfet_01v8 ad=0.38322 pd=2.88 as=0.30812 ps=1.74 w=1.245 l=0.15
X122 a_2786_n768# a_106_n774# GND GND sky130_fd_pr__nfet_01v8 ad=0.19845 pd=1.3 as=0.21465 ps=2.15 w=0.81 l=0.15
X123 a_106_n774# A0 VDD VDD sky130_fd_pr__pfet_01v8 ad=0.45325 pd=1.995 as=0.34317 ps=3.12 w=1.295 l=0.15
X124 a_1127_n67# a_734_n720# VDD VDD sky130_fd_pr__pfet_01v8 ad=0.62825 pd=2.495 as=0.27082 ps=2.135 w=1.795 l=0.15
X125 a_3372_n67# a_3021_n774# VDD VDD sky130_fd_pr__pfet_01v8 ad=0.2156 pd=1.37 as=0.20458 ps=1.635 w=0.88 l=0.15
X126 a_1799_n768# a_1404_n844# GND GND sky130_fd_pr__nfet_01v8 ad=0.2835 pd=1.51 as=0.18805 ps=1.53 w=0.81 l=0.15
X127 VDD a_4714_n67# Sum1 VDD sky130_fd_pr__pfet_01v8 ad=0.6731 pd=5.61 as=0.889 ps=3.24 w=2.54 l=0.15
X128 a_8616_n768# a_5936_n774# GND GND sky130_fd_pr__nfet_01v8 ad=0.19845 pd=1.3 as=0.21465 ps=2.15 w=0.81 l=0.15
X129 a_5114_n768# a_4319_n844# a_5031_n768# GND sky130_fd_pr__nfet_01v8 ad=0.20048 pd=1.305 as=0.21465 ps=2.15 w=0.81 l=0.15
X130 a_1799_n67# a_1404_n844# VDD VDD sky130_fd_pr__pfet_01v8 ad=0.43575 pd=1.945 as=0.28915 ps=2.17 w=1.245 l=0.15
X131 VDD B3 a_8851_n774# VDD sky130_fd_pr__pfet_01v8 ad=0.20458 pd=1.635 as=0.45325 ps=1.995 w=1.295 l=0.15
X132 a_2426_n935# a_2116_n768# GND GND sky130_fd_pr__nfet_01v8 ad=0.57575 pd=2.345 as=0.24833 ps=1.985 w=1.645 l=0.15
X133 a_7629_n768# a_7234_n844# GND GND sky130_fd_pr__nfet_01v8 ad=0.2835 pd=1.51 as=0.18805 ps=1.53 w=0.81 l=0.15
X134 a_9872_n67# a_9479_n720# VDD VDD sky130_fd_pr__pfet_01v8 ad=0.62825 pd=2.495 as=0.27082 ps=2.135 w=1.795 l=0.15
X135 a_4714_n67# a_4042_n67# a_4714_n768# GND sky130_fd_pr__nfet_01v8 ad=0.37665 pd=2.55 as=0.2835 ps=1.51 w=0.81 l=0.15
X136 VDD A0 a_457_n67# VDD sky130_fd_pr__pfet_01v8 ad=0.2332 pd=2.29 as=0.2156 ps=1.37 w=0.88 l=0.15
X137 a_8029_n768# a_7234_n844# a_7946_n768# GND sky130_fd_pr__nfet_01v8 ad=0.20048 pd=1.305 as=0.21465 ps=2.15 w=0.81 l=0.15
X138 VDD a_1404_n844# a_2786_n67# VDD sky130_fd_pr__pfet_01v8 ad=0.32993 pd=3.02 as=0.30503 ps=1.735 w=1.245 l=0.15
X139 Sum1 a_4714_n67# a_5341_n935# GND sky130_fd_pr__nfet_01v8 ad=0.43593 pd=3.82 as=0.57575 ps=2.345 w=1.645 l=0.15
X140 Sum1 a_5031_n768# VDD VDD sky130_fd_pr__pfet_01v8 ad=0.889 pd=3.24 as=0.38322 ps=2.88 w=2.54 l=0.15
X141 a_7234_n844# a_6957_n67# VDD VDD sky130_fd_pr__pfet_01v8 ad=0.6405 pd=2.53 as=0.86925 ps=4.61 w=1.83 l=0.15
X142 VDD a_8616_n67# a_10861_n768# VDD sky130_fd_pr__pfet_01v8 ad=0.38322 pd=2.88 as=0.30812 ps=1.74 w=1.245 l=0.15
X143 a_457_n720# a_106_n774# GND GND sky130_fd_pr__nfet_01v8 ad=0.13965 pd=1.06 as=0.13268 ps=1.18 w=0.57 l=0.15
C0 a_106_n774# Sum0 0.10697f
C1 a_7234_n844# a_8616_n67# 0.13354f
C2 A0 a_734_n720# 0.01667f
C3 a_8616_n768# a_8616_n67# 0.01858f
C4 a_10149_n844# Sum3 0.05185f
C5 A1 a_3649_n720# 0.01667f
C6 a_7629_n67# A3 0.00513f
C7 A1 a_3104_n774# 0
C8 a_5936_n774# Sum1 0
C9 a_3649_n720# a_2786_n67# 0.04214f
C10 A2 a_6019_n774# 0
C11 a_2786_n67# a_3104_n774# 0
C12 a_4446_n844# a_4714_n67# 0
C13 a_5936_n774# a_7629_n768# 0.00552f
C14 a_1531_n844# a_106_n774# 0.00773f
C15 Sum2 a_8029_n768# 0
C16 Sum3 a_8616_n67# 0.02541f
C17 a_7629_n67# a_9872_n67# 0
C18 a_4042_n839# Sum0 0
C19 a_7629_n67# a_8851_n774# 0
C20 a_6564_n720# a_4714_n67# 0
C21 a_7234_n844# a_9479_n720# 0
C22 VDD B0 0.11355f
C23 a_5341_n935# a_4042_n67# 0
C24 a_3372_n67# a_1127_n67# 0
C25 a_1404_n844# a_1127_n67# 0.39034f
C26 Sum2 a_9202_n67# 0
C27 a_106_n774# a_859_n720# 0.00496f
C28 VDD a_734_n720# 0.20724f
C29 A2 a_4042_n67# 0
C30 a_1799_n67# a_4042_n67# 0
C31 Sum2 a_8934_n774# 0
C32 Sum3 a_9479_n720# 0
C33 Sum0 a_2116_n768# 0.10816f
C34 a_5936_n774# B2 0.18646f
C35 a_10276_n844# a_9872_n67# 0.00102f
C36 a_4446_n844# a_4042_n67# 0.00102f
C37 a_10276_n844# a_8851_n774# 0.00773f
C38 a_8616_n67# a_7946_n768# 0.00293f
C39 a_5114_n768# a_4042_n67# 0
C40 a_4714_n67# a_3021_n774# 0.0701f
C41 a_5701_n67# a_7361_n844# 0.00138f
C42 a_1404_n844# a_1127_n839# 0
C43 a_106_n774# B0 0.27199f
C44 a_5701_n67# A2 0.03776f
C45 Sum2 a_6287_n67# 0
C46 B1 VDD 0.11367f
C47 B3 Sum2 0
C48 a_9202_n720# a_8616_n67# 0
C49 a_1799_n67# A0 0
C50 a_106_n774# a_734_n720# 0.10402f
C51 a_5701_n67# a_7234_n844# 0.20984f
C52 Sum2 A3 0
C53 a_457_n67# a_1127_n67# 0.17033f
C54 Sum2 a_9872_n67# 0
C55 A1 Cin 0
C56 Sum2 a_8851_n774# 0
C57 Cin a_2786_n67# 0
C58 a_5701_n67# a_6564_n720# 0.04214f
C59 a_4319_n844# a_6287_n67# 0.0046f
C60 a_6957_n67# a_4714_n67# 0
C61 B1 Sum1 0
C62 a_3021_n774# a_4042_n67# 0.04679f
C63 a_6957_n67# a_8616_n67# 0
C64 B0 a_2116_n768# 0
C65 Cin a_3649_n720# 0
C66 a_11531_n768# Cout 0.01858f
C67 VDD A2 0.14885f
C68 a_1799_n67# VDD 0.27027f
C69 a_189_n774# B0 0
C70 B1 a_106_n774# 0
C71 Sum0 B0 0
C72 VDD a_7234_n844# 0.6735f
C73 a_734_n720# a_2116_n768# 0
C74 Sum3 a_11171_n935# 0.04565f
C75 a_457_n67# a_1127_n839# 0
C76 Sum0 a_734_n720# 0
C77 Sum1 a_5341_n935# 0.04565f
C78 Sum3 VDD 0.3887f
C79 a_5701_n67# a_7946_n768# 0.19341f
C80 a_5701_n67# a_3021_n774# 0.04833f
C81 a_6564_n720# VDD 0.20746f
C82 a_5031_n768# a_3372_n67# 0
C83 Sum1 A2 0
C84 B0 a_859_n720# 0
C85 A1 a_3372_n67# 0.10657f
C86 a_7629_n67# a_8256_n935# 0
C87 A1 a_1404_n844# 0.03417f
C88 a_2786_n67# a_3372_n67# 0.03249f
C89 a_9872_n839# Sum2 0
C90 a_4319_n844# a_5031_n768# 0.11187f
C91 a_1404_n844# a_2786_n67# 0.13354f
C92 B1 a_2116_n768# 0.00204f
C93 a_106_n774# a_1799_n67# 0.0701f
C94 a_859_n720# a_734_n720# 0.01015f
C95 a_3649_n720# a_3372_n67# 0.31033f
C96 A1 a_4319_n844# 0
C97 a_7629_n768# a_7234_n844# 0
C98 a_3372_n67# a_3104_n774# 0
C99 a_1404_n844# a_3649_n720# 0
C100 a_4319_n844# a_2786_n67# 0.20984f
C101 B1 Sum0 0
C102 a_10149_n844# a_9202_n67# 0.0317f
C103 a_5114_n768# Sum1 0
C104 a_10149_n844# a_10544_n67# 0.30759f
C105 a_3649_n720# a_4319_n844# 0.0012f
C106 VDD a_7946_n768# 0.26746f
C107 a_6564_n720# Sum1 0
C108 a_3021_n774# VDD 0.34459f
C109 a_7629_n67# Sum2 0.13741f
C110 a_8616_n67# a_9202_n67# 0.03249f
C111 a_8616_n67# a_10544_n67# 0.05573f
C112 a_5701_n67# a_6957_n67# 0.22489f
C113 B2 A2 0.10224f
C114 a_8934_n774# a_8616_n67# 0
C115 B0 a_734_n720# 0.19416f
C116 a_5701_n67# a_6287_n720# 0
C117 a_1799_n67# a_2116_n768# 0.26513f
C118 B2 a_7234_n844# 0
C119 B1 a_3774_n720# 0
C120 a_3021_n774# a_4714_n768# 0.00552f
C121 a_1799_n67# Sum0 0.13741f
C122 a_9479_n720# a_9202_n67# 0.31033f
C123 a_9479_n720# a_10544_n67# 0.00318f
C124 a_5936_n774# a_7361_n844# 0.00773f
C125 a_2199_n768# a_1127_n67# 0
C126 a_3021_n774# Sum1 0.10697f
C127 a_10149_n844# B3 0
C128 a_2786_n67# a_457_n67# 0
C129 a_5936_n774# A2 0.20289f
C130 a_1531_n844# a_1799_n67# 0
C131 a_6564_n720# B2 0.19171f
C132 a_6957_n67# VDD 0.41283f
C133 a_106_n774# a_3021_n774# 0.00765f
C134 a_10149_n844# A3 0
C135 a_4714_n67# a_6287_n67# 0
C136 a_5936_n774# a_7234_n844# 0.11185f
C137 a_6287_n67# a_8616_n67# 0
C138 a_5936_n774# a_8616_n768# 0.00297f
C139 Sum2 a_8256_n935# 0.04565f
C140 Sum3 Cout 0.02966f
C141 a_10149_n844# a_10861_n768# 0.11187f
C142 B3 a_8616_n67# 0.13352f
C143 A3 a_8616_n67# 0.03776f
C144 a_10149_n844# a_9872_n67# 0.38789f
C145 a_10149_n844# a_8851_n774# 0.11185f
C146 A0 a_1127_n67# 0
C147 a_6287_n67# a_6019_n774# 0
C148 a_4042_n839# a_3021_n774# 0.00759f
C149 a_10861_n768# a_8616_n67# 0.19341f
C150 a_5701_n67# a_8029_n768# 0.00105f
C151 a_5701_n67# a_6689_n720# 0
C152 a_5936_n774# a_6564_n720# 0.08898f
C153 B3 a_9479_n720# 0.19171f
C154 a_9872_n67# a_8616_n67# 0.22489f
C155 a_8616_n67# a_8851_n774# 0.71556f
C156 Cin a_3372_n67# 0
C157 B2 a_7946_n768# 0
C158 Cin a_1404_n844# 0.18314f
C159 a_6957_n67# Sum1 0
C160 a_9479_n720# A3 0.01667f
C161 a_3021_n774# B2 0
C162 a_5701_n67# a_9202_n67# 0
C163 a_6957_n67# a_7629_n768# 0
C164 a_3021_n774# a_2116_n768# 0
C165 a_10544_n768# a_10544_n67# 0.01851f
C166 a_1799_n768# a_1404_n844# 0
C167 a_10149_n844# a_10944_n768# 0
C168 a_10861_n768# a_9479_n720# 0
C169 a_6287_n67# a_4042_n67# 0
C170 a_1799_n67# B0 0
C171 a_4714_n67# a_5031_n768# 0.26513f
C172 a_3021_n774# Sum0 0
C173 a_9872_n67# a_9479_n720# 0.08357f
C174 VDD a_1127_n67# 0.41282f
C175 a_9479_n720# a_8851_n774# 0.08898f
C176 a_2786_n768# a_106_n774# 0.00297f
C177 A1 a_4714_n67# 0
C178 a_5936_n774# a_7946_n768# 0.05056f
C179 a_10944_n768# a_8616_n67# 0.00105f
C180 B3 a_9604_n720# 0
C181 a_1799_n67# a_734_n720# 0.00318f
C182 a_4714_n67# a_2786_n67# 0.05573f
C183 Sum3 a_11531_n768# 0
C184 Sum1 a_6957_n839# 0
C185 a_5936_n774# a_3021_n774# 0.00765f
C186 a_10544_n67# a_11171_n935# 0
C187 a_3649_n720# a_4714_n67# 0.00318f
C188 a_9872_n839# a_10149_n844# 0
C189 VDD a_9202_n67# 0.32551f
C190 VDD a_10544_n67# 0.26938f
C191 a_6957_n67# B2 0.02726f
C192 a_5701_n67# a_6287_n67# 0.03249f
C193 a_9604_n720# a_9872_n67# 0
C194 a_1404_n844# a_3372_n67# 0.0046f
C195 a_9604_n720# a_8851_n774# 0.00496f
C196 B3 a_5701_n67# 0
C197 a_3021_n774# a_3774_n720# 0.00496f
C198 VDD a_8934_n774# 0
C199 a_4319_n844# a_3372_n67# 0.0317f
C200 a_5701_n67# A3 0
C201 B1 a_1799_n67# 0
C202 a_1404_n844# a_4319_n844# 0
C203 a_5031_n768# a_4042_n67# 0.01648f
C204 a_106_n774# a_1127_n67# 0.10876f
C205 Cin a_457_n67# 0
C206 A1 a_4042_n67# 0
C207 a_2786_n768# Sum0 0
C208 a_2786_n67# a_4042_n67# 0.22489f
C209 a_9872_n839# a_9479_n720# 0
C210 a_5936_n774# a_6957_n67# 0.04679f
C211 a_5701_n768# a_4319_n844# 0
C212 a_5701_n67# a_8851_n774# 0
C213 a_10544_n768# a_9872_n67# 0
C214 a_10544_n768# a_8851_n774# 0.00552f
C215 a_3649_n720# a_4042_n67# 0.08357f
C216 a_7629_n67# a_8616_n67# 0.01134f
C217 a_5936_n774# a_6287_n720# 0.00509f
C218 a_6287_n67# VDD 0.32551f
C219 B3 VDD 0.11367f
C220 a_10861_n768# a_11171_n935# 0.00239f
C221 a_2426_n935# a_106_n774# 0.01f
C222 a_5701_n67# a_5031_n768# 0.00293f
C223 a_7361_n844# a_7234_n844# 0.02689f
C224 a_106_n774# a_1127_n839# 0.00759f
C225 VDD A3 0.14885f
C226 a_10149_n844# a_10276_n844# 0.02689f
C227 a_9872_n67# a_11171_n935# 0
C228 a_7629_n67# a_9479_n720# 0
C229 a_1127_n67# a_2116_n768# 0.01648f
C230 a_5936_n774# a_6957_n839# 0.00759f
C231 a_11171_n935# a_8851_n774# 0.01f
C232 a_10861_n768# VDD 0.26746f
C233 a_5701_n67# a_2786_n67# 0
C234 a_7234_n844# A2 0
C235 Sum0 a_1127_n67# 0
C236 a_6689_n720# B2 0
C237 VDD a_9872_n67# 0.41283f
C238 VDD a_8851_n774# 0.34454f
C239 a_1404_n844# a_457_n67# 0.0317f
C240 a_10276_n844# a_8616_n67# 0.00138f
C241 a_7234_n844# a_8616_n768# 0
C242 a_6287_n67# Sum1 0
C243 a_1531_n844# a_1127_n67# 0.00102f
C244 B1 a_3021_n774# 0.18646f
C245 a_6564_n720# A2 0.01667f
C246 a_2426_n935# a_2116_n768# 0.00239f
C247 a_5031_n768# VDD 0.26746f
C248 a_5936_n774# a_8029_n768# 0.0039f
C249 Cout a_9202_n67# 0
C250 a_5936_n774# a_6689_n720# 0.00496f
C251 Cout a_10544_n67# 0.01134f
C252 a_457_n720# a_457_n67# 0.00732f
C253 a_859_n720# a_1127_n67# 0
C254 a_6564_n720# a_7234_n844# 0.0012f
C255 A1 VDD 0.14885f
C256 a_2426_n935# Sum0 0.04565f
C257 a_2786_n67# VDD 0.32842f
C258 a_5936_n774# a_9202_n67# 0
C259 a_3649_n720# VDD 0.20746f
C260 VDD a_3104_n774# 0
C261 a_3021_n774# a_5341_n935# 0.01f
C262 Sum2 a_8616_n67# 0.03435f
C263 a_7629_n67# a_5701_n67# 0.05573f
C264 a_6287_n67# B2 0.06381f
C265 a_3021_n774# A2 0
C266 a_5031_n768# Sum1 0.10816f
C267 a_3021_n774# a_1799_n67# 0
C268 a_7234_n844# a_7946_n768# 0.11187f
C269 B0 a_1127_n67# 0.02726f
C270 a_4714_n67# a_3372_n67# 0
C271 Sum2 a_9479_n720# 0
C272 a_2786_n67# Sum1 0.02541f
C273 a_2199_n768# Cin 0.00105f
C274 A1 a_106_n774# 0
C275 a_3649_n720# Sum1 0
C276 a_4446_n844# a_3021_n774# 0.00773f
C277 a_1127_n67# a_734_n720# 0.08357f
C278 a_106_n774# a_2786_n67# 0.04833f
C279 a_4714_n67# a_4319_n844# 0.30759f
C280 a_5114_n768# a_3021_n774# 0.0039f
C281 a_5936_n774# a_6287_n67# 0.1092f
C282 a_6564_n720# a_7946_n768# 0
C283 a_106_n774# a_3649_n720# 0
C284 B3 a_5936_n774# 0
C285 a_7629_n67# VDD 0.27027f
C286 a_10861_n768# Cout 0.00293f
C287 a_6564_n720# a_3021_n774# 0
C288 a_6957_n67# a_7361_n844# 0.00102f
C289 a_5936_n774# A3 0
C290 a_9872_n67# Cout 0
C291 Cout a_8851_n774# 0.04775f
C292 a_6957_n67# A2 0
C293 Cin A0 0
C294 a_3649_n720# a_4042_n839# 0
C295 a_3372_n720# a_3021_n774# 0.00509f
C296 a_5031_n768# B2 0.00204f
C297 a_6957_n67# a_8616_n768# 0
C298 a_6957_n67# a_7234_n844# 0.38789f
C299 a_5936_n774# a_8851_n774# 0.00765f
C300 A2 a_6287_n720# 0
C301 a_3372_n67# a_4042_n67# 0.16969f
C302 A1 a_2116_n768# 0
C303 a_1404_n844# a_4042_n67# 0
C304 a_1127_n839# a_734_n720# 0
C305 a_2786_n67# B2 0
C306 a_2786_n67# a_2116_n768# 0.00293f
C307 a_4319_n844# a_4042_n67# 0.38789f
C308 a_2199_n768# a_1404_n844# 0
C309 A1 Sum0 0
C310 a_5701_n67# Sum2 0.02541f
C311 a_2786_n67# Sum0 0.03435f
C312 a_7629_n67# a_7629_n768# 0.01851f
C313 a_5701_n768# a_4042_n67# 0
C314 a_5936_n774# a_5031_n768# 0
C315 a_6957_n67# a_6564_n720# 0.08357f
C316 a_3649_n720# Sum0 0
C317 Sum0 a_3104_n774# 0
C318 Cin VDD 0.11779f
C319 a_6957_n839# a_7234_n844# 0
C320 a_5936_n774# a_2786_n67# 0
C321 a_5701_n67# a_3372_n67# 0
C322 a_1799_n67# a_1127_n67# 0.09702f
C323 a_1404_n844# A0 0
C324 a_11531_n768# a_9872_n67# 0
C325 a_11531_n768# a_8851_n774# 0.00297f
C326 a_5701_n67# a_4319_n844# 0.13354f
C327 a_6564_n720# a_6957_n839# 0
C328 Sum2 VDD 0.38871f
C329 a_5701_n768# a_5701_n67# 0.01858f
C330 a_6957_n67# a_7946_n768# 0.01648f
C331 a_3774_n720# a_2786_n67# 0
C332 a_7629_n67# B2 0
C333 a_8029_n768# a_7234_n844# 0
C334 a_3649_n720# a_3774_n720# 0.01015f
C335 a_457_n720# A0 0
C336 Cin a_106_n774# 0.18446f
C337 a_2786_n768# a_3021_n774# 0
C338 a_2426_n935# a_1799_n67# 0
C339 a_3372_n67# VDD 0.32551f
C340 a_7234_n844# a_9202_n67# 0.0046f
C341 a_10149_n844# a_8616_n67# 0.20984f
C342 a_1404_n844# VDD 0.6735f
C343 a_1799_n768# a_106_n774# 0.00552f
C344 a_7629_n67# a_5936_n774# 0.0701f
C345 a_4319_n844# VDD 0.6735f
C346 a_6564_n720# a_6689_n720# 0.01015f
C347 Sum3 a_9202_n67# 0
C348 Sum3 a_10544_n67# 0.13741f
C349 a_10149_n844# a_9479_n720# 0.0012f
C350 a_457_n67# A0 0.10657f
C351 Cin a_2116_n768# 0.19341f
C352 a_4319_n844# a_4714_n768# 0
C353 a_6287_n67# A2 0.10657f
C354 a_3372_n67# Sum1 0
C355 a_9479_n720# a_8616_n67# 0.04214f
C356 a_8029_n768# a_7946_n768# 0.01666f
C357 Cin Sum0 0.02541f
C358 a_106_n774# a_3372_n67# 0
C359 a_6287_n67# a_7234_n844# 0.0317f
C360 B1 a_5031_n768# 0
C361 a_1404_n844# a_106_n774# 0.11776f
C362 a_4319_n844# Sum1 0.05171f
C363 B3 a_7234_n844# 0.00113f
C364 a_5701_n768# Sum1 0
C365 B1 A1 0.10224f
C366 a_5936_n774# a_8256_n935# 0.01f
C367 B1 a_2786_n67# 0.13352f
C368 a_7946_n768# a_9202_n67# 0
C369 Cin a_1531_n844# 0.00138f
C370 a_7234_n844# A3 0.03417f
C371 a_6957_n67# a_6957_n839# 0.0325f
C372 a_4714_n67# a_4042_n67# 0.09702f
C373 Sum2 B2 0
C374 B1 a_3649_n720# 0.19171f
C375 B3 Sum3 0
C376 a_4042_n839# a_3372_n67# 0
C377 B1 a_3104_n774# 0
C378 a_457_n67# VDD 0.32524f
C379 a_6564_n720# a_6287_n67# 0.31033f
C380 a_9604_n720# a_8616_n67# 0
C381 a_106_n774# a_457_n720# 0.00509f
C382 a_9872_n67# a_7234_n844# 0
C383 a_5031_n768# a_5341_n935# 0.00239f
C384 a_7234_n844# a_8851_n774# 0.0095f
C385 a_8616_n768# a_8851_n774# 0
C386 a_4042_n839# a_4319_n844# 0
C387 a_9202_n720# a_9202_n67# 0.00732f
C388 a_10861_n768# Sum3 0.10816f
C389 a_10149_n844# a_10544_n768# 0
C390 a_5031_n768# A2 0
C391 a_3372_n67# a_2116_n768# 0
C392 a_5936_n774# Sum2 0.10697f
C393 Sum3 a_9872_n67# 0
C394 a_1404_n844# a_2116_n768# 0.11187f
C395 Sum3 a_8851_n774# 0.10697f
C396 a_2786_n768# a_1127_n67# 0
C397 a_6957_n67# a_8029_n768# 0
C398 a_9604_n720# a_9479_n720# 0.01015f
C399 a_4319_n844# B2 0.00113f
C400 a_6957_n67# a_6689_n720# 0
C401 A1 a_1799_n67# 0.00513f
C402 a_5701_n67# a_4714_n67# 0.01134f
C403 a_3372_n67# Sum0 0
C404 a_5701_n67# a_8616_n67# 0
C405 a_2786_n67# A2 0
C406 a_1799_n67# a_2786_n67# 0.01134f
C407 a_1404_n844# Sum0 0.05171f
C408 a_6287_n67# a_7946_n768# 0
C409 B3 a_7946_n768# 0.00204f
C410 a_3649_n720# a_1799_n67# 0
C411 a_6957_n67# a_9202_n67# 0
C412 a_3021_n774# a_6287_n67# 0
C413 a_5114_n768# a_5031_n768# 0.01666f
C414 a_1531_n844# a_1404_n844# 0.02689f
C415 a_106_n774# a_457_n67# 0.11724f
C416 Cin B0 0
C417 a_5701_n67# a_6019_n774# 0
C418 A3 a_7946_n768# 0
C419 a_4446_n844# a_2786_n67# 0.00138f
C420 a_10944_n768# Sum3 0
C421 a_5701_n67# a_9479_n720# 0
C422 a_5114_n768# a_2786_n67# 0.00105f
C423 a_10149_n844# VDD 0.66921f
C424 a_5936_n774# a_4319_n844# 0.0095f
C425 Cin a_734_n720# 0
C426 a_5701_n768# a_5936_n774# 0
C427 a_6564_n720# a_2786_n67# 0
C428 a_7946_n768# a_8851_n774# 0
C429 a_9202_n720# A3 0
C430 a_4714_n67# VDD 0.27027f
C431 VDD a_8616_n67# 0.32834f
C432 a_7629_n67# a_7361_n844# 0
C433 a_3372_n720# A1 0
C434 a_5701_n67# a_4042_n67# 0
C435 a_3372_n720# a_2786_n67# 0
C436 a_9202_n720# a_8851_n774# 0.00509f
C437 a_7629_n67# A2 0
C438 a_6957_n67# a_6287_n67# 0.16969f
C439 a_457_n67# a_2116_n768# 0
C440 VDD a_6019_n774# 0
C441 a_3021_n774# a_5031_n768# 0.05056f
C442 VDD a_9479_n720# 0.20746f
C443 a_7629_n67# a_7234_n844# 0.30759f
C444 a_4714_n67# a_4714_n768# 0.01851f
C445 B1 Cin 0
C446 a_189_n774# a_457_n67# 0
C447 a_457_n67# Sum0 0
C448 a_6957_n67# A3 0
C449 a_6287_n67# a_6287_n720# 0.00732f
C450 A1 a_3021_n774# 0.20289f
C451 a_1404_n844# B0 0
C452 a_3021_n774# a_2786_n67# 0.71556f
C453 a_2426_n935# a_1127_n67# 0
C454 a_4714_n67# Sum1 0.13741f
C455 a_1127_n839# a_1127_n67# 0.0325f
C456 a_3649_n720# a_3021_n774# 0.08898f
C457 a_3021_n774# a_3104_n774# 0.02979f
C458 a_1404_n844# a_734_n720# 0.0012f
C459 VDD a_4042_n67# 0.41283f
C460 a_6287_n67# a_6957_n839# 0
C461 a_7629_n67# a_6564_n720# 0.00318f
C462 a_10544_n67# a_9202_n67# 0
C463 Sum1 a_6019_n774# 0
C464 a_8934_n774# a_9202_n67# 0
C465 Cin a_1799_n67# 0.05573f
C466 a_4714_n768# a_4042_n67# 0
C467 B1 a_3372_n67# 0.06381f
C468 a_1799_n768# a_1799_n67# 0.01851f
C469 B1 a_1404_n844# 0.00113f
C470 a_7629_n67# a_7946_n768# 0.26513f
C471 Sum1 a_4042_n67# 0
C472 a_10149_n844# Cout 0.13192f
C473 a_5701_n67# VDD 0.32842f
C474 a_4714_n67# B2 0
C475 B1 a_4319_n844# 0
C476 VDD A0 0.14432f
C477 a_2786_n768# a_2786_n67# 0.01858f
C478 a_457_n67# B0 0.06626f
C479 Cout a_8616_n67# 0
C480 B3 a_9202_n67# 0.06381f
C481 B3 a_10544_n67# 0
C482 a_2199_n768# a_106_n774# 0.0039f
C483 B2 a_6019_n774# 0
C484 Sum2 a_7234_n844# 0.05171f
C485 Sum2 a_8616_n768# 0
C486 a_457_n67# a_734_n720# 0.31033f
C487 A3 a_9202_n67# 0.10657f
C488 A3 a_10544_n67# 0
C489 a_4042_n839# a_4042_n67# 0.0325f
C490 a_5936_n774# a_4714_n67# 0
C491 B3 a_8934_n774# 0
C492 a_5936_n774# a_8616_n67# 0.04833f
C493 a_10861_n768# a_9202_n67# 0
C494 a_10861_n768# a_10544_n67# 0.26513f
C495 a_5701_n67# Sum1 0.03435f
C496 a_1799_n67# a_3372_n67# 0
C497 A3 a_8934_n774# 0
C498 a_1404_n844# a_1799_n67# 0.30759f
C499 a_9872_n67# a_9202_n67# 0.16969f
C500 a_9872_n67# a_10544_n67# 0.09702f
C501 a_9202_n67# a_8851_n774# 0.1092f
C502 A1 a_1127_n67# 0
C503 a_10544_n67# a_8851_n774# 0.0701f
C504 a_6564_n720# Sum2 0
C505 a_8256_n935# a_7946_n768# 0.00239f
C506 a_5936_n774# a_6019_n774# 0.02979f
C507 a_4319_n844# A2 0.03417f
C508 a_2786_n67# a_1127_n67# 0
C509 a_7629_n67# a_6957_n67# 0.09702f
C510 a_106_n774# A0 0.2192f
C511 a_5936_n774# a_9479_n720# 0
C512 a_8934_n774# a_8851_n774# 0.02979f
C513 Cin a_3021_n774# 0
C514 a_4319_n844# a_7234_n844# 0
C515 Sum0 a_4042_n67# 0
C516 a_2199_n768# a_2116_n768# 0.01666f
C517 a_10149_n844# a_11531_n768# 0
C518 a_4446_n844# a_4319_n844# 0.02689f
C519 a_2199_n768# Sum0 0
C520 a_5114_n768# a_4319_n844# 0
C521 B3 A3 0.10224f
C522 Sum1 VDD 0.38871f
C523 Sum2 a_7946_n768# 0.10816f
C524 B3 a_10861_n768# 0
C525 a_6564_n720# a_4319_n844# 0
C526 a_3372_n720# a_3372_n67# 0.00732f
C527 a_5701_n67# B2 0.13352f
C528 a_106_n774# VDD 0.34301f
C529 B3 a_9872_n67# 0.02726f
C530 B3 a_8851_n774# 0.18646f
C531 a_6957_n67# a_8256_n935# 0
C532 a_9872_n839# a_9202_n67# 0
C533 a_3774_n720# a_4042_n67# 0
C534 a_9872_n67# A3 0
C535 a_189_n774# A0 0
C536 A3 a_8851_n774# 0.20289f
C537 a_1799_n67# a_457_n67# 0
C538 a_10861_n768# a_9872_n67# 0.01648f
C539 a_3021_n774# a_3372_n67# 0.1092f
C540 a_10861_n768# a_8851_n774# 0.05056f
C541 a_5031_n768# a_6287_n67# 0
C542 a_1404_n844# a_3021_n774# 0.0095f
C543 a_5936_n774# a_5701_n67# 0.71556f
C544 a_9872_n67# a_8851_n774# 0.04679f
C545 a_3021_n774# a_4319_n844# 0.11185f
C546 a_6287_n67# a_2786_n67# 0
C547 B2 VDD 0.11367f
C548 a_5701_n768# a_3021_n774# 0.00297f
C549 VDD a_2116_n768# 0.26746f
C550 a_7629_n67# a_9202_n67# 0
C551 a_6957_n67# Sum2 0
C552 B1 a_4714_n67# 0
C553 a_189_n774# VDD 0
C554 a_10944_n768# a_10861_n768# 0.01666f
C555 Sum0 VDD 0.38871f
C556 VDD Cout 0.20216f
C557 a_10944_n768# a_9872_n67# 0
C558 a_10944_n768# a_8851_n774# 0.0039f
C559 a_5936_n774# VDD 0.34459f
C560 Cin a_1127_n67# 0.10922f
C561 B2 Sum1 0
C562 a_4714_n67# a_5341_n935# 0
C563 a_6957_n67# a_4319_n844# 0
C564 a_1799_n768# a_1127_n67# 0
C565 a_2786_n768# a_1404_n844# 0
C566 a_10276_n844# a_10544_n67# 0
C567 a_10149_n844# a_7234_n844# 0
C568 a_5031_n768# a_2786_n67# 0.19341f
C569 a_9872_n839# a_9872_n67# 0.0325f
C570 B0 A0 0.10289f
C571 a_4714_n67# A2 0.00513f
C572 a_9872_n839# a_8851_n774# 0.00759f
C573 a_106_n774# a_2116_n768# 0.05056f
C574 a_7629_n67# a_6287_n67# 0
C575 B3 a_7629_n67# 0
C576 a_3649_n720# a_5031_n768# 0
C577 B1 a_4042_n67# 0.02726f
C578 A1 a_2786_n67# 0.03776f
C579 a_106_n774# a_189_n774# 0.02979f
C580 Cout GND 0.3103f
C581 Sum3 GND 0.29719f
C582 B3 GND 0.58094f
C583 A3 GND 0.61352f
C584 Sum2 GND 0.28658f
C585 B2 GND 0.58094f
C586 A2 GND 0.61352f
C587 Sum1 GND 0.28658f
C588 B1 GND 0.58094f
C589 A1 GND 0.61352f
C590 Sum0 GND 0.28658f
C591 B0 GND 0.59951f
C592 A0 GND 0.6971f
C593 Cin GND 0.58309f
C594 VDD GND 28.3267f
C595 a_11531_n768# GND 0.0169f **FLOATING
C596 a_11171_n935# GND 0.04958f **FLOATING
C597 a_10944_n768# GND 0.01651f **FLOATING
C598 a_10544_n768# GND 0.02301f **FLOATING
C599 a_10276_n844# GND 0.03505f **FLOATING
C600 a_9872_n839# GND 0.03465f **FLOATING
C601 a_9604_n720# GND 0.01638f **FLOATING
C602 a_9202_n720# GND 0.01179f **FLOATING
C603 a_8934_n774# GND 0.02693f **FLOATING
C604 a_8616_n768# GND 0.0171f **FLOATING
C605 a_8256_n935# GND 0.04958f **FLOATING
C606 a_8029_n768# GND 0.01651f **FLOATING
C607 a_7629_n768# GND 0.02301f **FLOATING
C608 a_7361_n844# GND 0.03505f **FLOATING
C609 a_6957_n839# GND 0.03465f **FLOATING
C610 a_6689_n720# GND 0.01638f **FLOATING
C611 a_6287_n720# GND 0.01179f **FLOATING
C612 a_6019_n774# GND 0.02693f **FLOATING
C613 a_5701_n768# GND 0.0171f **FLOATING
C614 a_5341_n935# GND 0.04958f **FLOATING
C615 a_5114_n768# GND 0.01651f **FLOATING
C616 a_4714_n768# GND 0.02301f **FLOATING
C617 a_4446_n844# GND 0.03505f **FLOATING
C618 a_4042_n839# GND 0.03465f **FLOATING
C619 a_3774_n720# GND 0.01638f **FLOATING
C620 a_3372_n720# GND 0.01179f **FLOATING
C621 a_3104_n774# GND 0.02693f **FLOATING
C622 a_2786_n768# GND 0.0171f **FLOATING
C623 a_2426_n935# GND 0.04958f **FLOATING
C624 a_2199_n768# GND 0.01651f **FLOATING
C625 a_1799_n768# GND 0.02301f **FLOATING
C626 a_1531_n844# GND 0.03505f **FLOATING
C627 a_1127_n839# GND 0.03465f **FLOATING
C628 a_859_n720# GND 0.01638f **FLOATING
C629 a_457_n720# GND 0.01179f **FLOATING
C630 a_189_n774# GND 0.02652f **FLOATING
C631 a_10149_n844# GND 1.11581f **FLOATING
C632 a_8851_n774# GND 1.39481f **FLOATING
C633 a_8616_n67# GND 0.82059f **FLOATING
C634 a_9872_n67# GND 0.81767f **FLOATING
C635 a_9202_n67# GND 0.45499f **FLOATING
C636 a_9479_n720# GND 0.42536f **FLOATING
C637 a_7234_n844# GND 1.03619f **FLOATING
C638 a_5936_n774# GND 1.38315f **FLOATING
C639 a_5701_n67# GND 0.82019f **FLOATING
C640 a_6957_n67# GND 0.81767f **FLOATING
C641 a_6287_n67# GND 0.45499f **FLOATING
C642 a_6564_n720# GND 0.42536f **FLOATING
C643 a_4319_n844# GND 1.03619f **FLOATING
C644 a_3021_n774# GND 1.38315f **FLOATING
C645 a_2786_n67# GND 0.82019f **FLOATING
C646 a_4042_n67# GND 0.81767f **FLOATING
C647 a_3372_n67# GND 0.45499f **FLOATING
C648 a_3649_n720# GND 0.42536f **FLOATING
C649 a_1404_n844# GND 1.03619f **FLOATING
C650 a_106_n774# GND 1.55561f **FLOATING
C651 a_1127_n67# GND 0.82271f **FLOATING
C652 a_457_n67# GND 0.46378f **FLOATING
C653 a_734_n720# GND 0.42647f **FLOATING
C654 a_10544_n67# GND 0.50295f **FLOATING
C655 a_10861_n768# GND 0.43286f **FLOATING
C656 a_7629_n67# GND 0.48999f **FLOATING
C657 a_7946_n768# GND 0.42683f **FLOATING
C658 a_4714_n67# GND 0.48999f **FLOATING
C659 a_5031_n768# GND 0.42683f **FLOATING
C660 a_1799_n67# GND 0.48999f **FLOATING
C661 a_2116_n768# GND 0.42683f **FLOATING
